* NGSPICE file created from ztimer.ext - technology: gf180mcuD

* Black-box entry subcircuit for gf180mcu_as_sc_mcu7t3v3__fillcap_16 abstract view
.subckt gf180mcu_as_sc_mcu7t3v3__fillcap_16 VDD VNW VPW VSS
.ends

* Black-box entry subcircuit for gf180mcu_as_sc_mcu7t3v3__fill_2 abstract view
.subckt gf180mcu_as_sc_mcu7t3v3__fill_2 VDD VNW VPW VSS
.ends

* Black-box entry subcircuit for gf180mcu_as_sc_mcu7t3v3__fillcap_4 abstract view
.subckt gf180mcu_as_sc_mcu7t3v3__fillcap_4 VDD VNW VPW VSS
.ends

* Black-box entry subcircuit for gf180mcu_as_sc_mcu7t3v3__fill_1 abstract view
.subckt gf180mcu_as_sc_mcu7t3v3__fill_1 VDD VNW VPW VSS
.ends

* Black-box entry subcircuit for gf180mcu_as_sc_mcu7t3v3__tap_2 abstract view
.subckt gf180mcu_as_sc_mcu7t3v3__tap_2 VDD VSS
.ends

* Black-box entry subcircuit for gf180mcu_as_sc_mcu7t3v3__dfsrtp_2 abstract view
.subckt gf180mcu_as_sc_mcu7t3v3__dfsrtp_2 VDD VNW VPW VSS CLK Q RN SN D
.ends

* Black-box entry subcircuit for gf180mcu_as_sc_mcu7t3v3__nor2_2 abstract view
.subckt gf180mcu_as_sc_mcu7t3v3__nor2_2 VDD VNW VPW VSS Y B A
.ends

* Black-box entry subcircuit for gf180mcu_as_sc_mcu7t3v3__fillcap_8 abstract view
.subckt gf180mcu_as_sc_mcu7t3v3__fillcap_8 VDD VNW VPW VSS
.ends

* Black-box entry subcircuit for gf180mcu_as_sc_mcu7t3v3__inv_2 abstract view
.subckt gf180mcu_as_sc_mcu7t3v3__inv_2 VDD VNW VPW VSS Y A
.ends

* Black-box entry subcircuit for gf180mcu_as_sc_mcu7t3v3__buff_2 abstract view
.subckt gf180mcu_as_sc_mcu7t3v3__buff_2 VDD VNW VPW VSS A Y
.ends

* Black-box entry subcircuit for gf180mcu_as_sc_mcu7t3v3__nor2b_2 abstract view
.subckt gf180mcu_as_sc_mcu7t3v3__nor2b_2 VDD VNW VPW VSS Y B A
.ends

* Black-box entry subcircuit for gf180mcu_as_sc_mcu7t3v3__buff_8 abstract view
.subckt gf180mcu_as_sc_mcu7t3v3__buff_8 VDD VNW VPW VSS A Y
.ends

* Black-box entry subcircuit for gf180mcu_as_sc_mcu7t3v3__clkbuff_12 abstract view
.subckt gf180mcu_as_sc_mcu7t3v3__clkbuff_12 VDD VNW VPW VSS A Y
.ends

* Black-box entry subcircuit for gf180mcu_as_sc_mcu7t3v3__tieh_4 abstract view
.subckt gf180mcu_as_sc_mcu7t3v3__tieh_4 VDD VNW VPW VSS ONE
.ends

* Black-box entry subcircuit for gf180mcu_as_sc_mcu7t3v3__clkbuff_4 abstract view
.subckt gf180mcu_as_sc_mcu7t3v3__clkbuff_4 VDD VNW VPW VSS A Y
.ends

* Black-box entry subcircuit for gf180mcu_as_sc_mcu7t3v3__or2_2 abstract view
.subckt gf180mcu_as_sc_mcu7t3v3__or2_2 VDD VNW VPW VSS B A Y
.ends

* Black-box entry subcircuit for gf180mcu_as_sc_mcu7t3v3__nand2_2 abstract view
.subckt gf180mcu_as_sc_mcu7t3v3__nand2_2 VDD VNW VPW VSS Y B A
.ends

* Black-box entry subcircuit for gf180mcu_as_sc_mcu7t3v3__nor3_2 abstract view
.subckt gf180mcu_as_sc_mcu7t3v3__nor3_2 VDD VNW VPW VSS A B C Y
.ends

* Black-box entry subcircuit for gf180mcu_as_sc_mcu7t3v3__and2_2 abstract view
.subckt gf180mcu_as_sc_mcu7t3v3__and2_2 VDD VNW VPW VSS B A Y
.ends

* Black-box entry subcircuit for gf180mcu_as_sc_mcu7t3v3__mux2_2 abstract view
.subckt gf180mcu_as_sc_mcu7t3v3__mux2_2 VDD VNW VPW VSS S B A Y
.ends

* Black-box entry subcircuit for gf180mcu_as_sc_mcu7t3v3__ao22_2 abstract view
.subckt gf180mcu_as_sc_mcu7t3v3__ao22_2 VDD VNW VPW VSS A B C D Y
.ends

* Black-box entry subcircuit for gf180mcu_as_sc_mcu7t3v3__ao211_2 abstract view
.subckt gf180mcu_as_sc_mcu7t3v3__ao211_2 VDD VNW VPW VSS A B C D Y
.ends

* Black-box entry subcircuit for gf180mcu_as_sc_mcu7t3v3__aoi22_2 abstract view
.subckt gf180mcu_as_sc_mcu7t3v3__aoi22_2 VDD VNW VPW VSS Y A B C D
.ends

* Black-box entry subcircuit for gf180mcu_as_sc_mcu7t3v3__nand3_2 abstract view
.subckt gf180mcu_as_sc_mcu7t3v3__nand3_2 VDD VNW VPW VSS A B C Y
.ends

* Black-box entry subcircuit for gf180mcu_as_sc_mcu7t3v3__xor2_2 abstract view
.subckt gf180mcu_as_sc_mcu7t3v3__xor2_2 VDD VNW VPW VSS B A Y
.ends

* Black-box entry subcircuit for gf180mcu_as_sc_mcu7t3v3__ao21_2 abstract view
.subckt gf180mcu_as_sc_mcu7t3v3__ao21_2 VDD VNW VPW VSS Y A B C
.ends

* Black-box entry subcircuit for gf180mcu_as_sc_mcu7t3v3__aoi21_2 abstract view
.subckt gf180mcu_as_sc_mcu7t3v3__aoi21_2 VDD VNW VPW VSS Y C B A
.ends

* Black-box entry subcircuit for gf180mcu_as_sc_mcu7t3v3__ao31_2 abstract view
.subckt gf180mcu_as_sc_mcu7t3v3__ao31_2 VDD VNW VPW VSS D A B C Y
.ends

* Black-box entry subcircuit for gf180mcu_as_sc_mcu7t3v3__aoi21b_2 abstract view
.subckt gf180mcu_as_sc_mcu7t3v3__aoi21b_2 VDD VNW VPW VSS Y C B A
.ends

.subckt ztimer VDD VSS cio_csb_i cio_sck_i cio_sd_i cio_sd_o clk_i rst_ni start_i
+ stop_i
XFILLER_39_244 VDD VDD VSS VSS gf180mcu_as_sc_mcu7t3v3__fillcap_16
XFILLER_22_177 VDD VDD VSS VSS gf180mcu_as_sc_mcu7t3v3__fill_2
XFILLER_36_247 VDD VDD VSS VSS gf180mcu_as_sc_mcu7t3v3__fillcap_16
XFILLER_36_225 VDD VDD VSS VSS gf180mcu_as_sc_mcu7t3v3__fillcap_16
XFILLER_3_34 VDD VDD VSS VSS gf180mcu_as_sc_mcu7t3v3__fillcap_16
XFILLER_33_228 VDD VDD VSS VSS gf180mcu_as_sc_mcu7t3v3__fillcap_16
XFILLER_33_206 VDD VDD VSS VSS gf180mcu_as_sc_mcu7t3v3__fillcap_4
XFILLER_26_291 VDD VDD VSS VSS gf180mcu_as_sc_mcu7t3v3__fill_1
XFILLER_18_247 VDD VDD VSS VSS gf180mcu_as_sc_mcu7t3v3__fillcap_16
XFILLER_6_107 VDD VDD VSS VSS gf180mcu_as_sc_mcu7t3v3__fillcap_16
XFILLER_12_87 VDD VDD VSS VSS gf180mcu_as_sc_mcu7t3v3__fill_1
XTAP_TAPCELL_ROW_34_223 VDD VSS gf180mcu_as_sc_mcu7t3v3__tap_2
XFILLER_24_228 VDD VDD VSS VSS gf180mcu_as_sc_mcu7t3v3__fill_2
XPHY_EDGE_ROW_20_Left_61 VDD VSS gf180mcu_as_sc_mcu7t3v3__tap_2
XTAP_TAPCELL_ROW_11_131 VDD VSS gf180mcu_as_sc_mcu7t3v3__tap_2
XTAP_TAPCELL_ROW_40_248 VDD VSS gf180mcu_as_sc_mcu7t3v3__tap_2
XFILLER_30_209 VDD VDD VSS VSS gf180mcu_as_sc_mcu7t3v3__fillcap_16
XFILLER_23_31 VDD VDD VSS VSS gf180mcu_as_sc_mcu7t3v3__fill_1
XFILLER_23_20 VDD VDD VSS VSS gf180mcu_as_sc_mcu7t3v3__fill_1
X_200_ VDD VDD VSS VSS _213_/CLK _200_/Q _211_/RN _200_/SN _200_/D gf180mcu_as_sc_mcu7t3v3__dfsrtp_2
X_131_ VDD VDD VSS VSS _149_/B _138_/B _213_/D gf180mcu_as_sc_mcu7t3v3__nor2_2
XFILLER_21_209 VDD VDD VSS VSS gf180mcu_as_sc_mcu7t3v3__fill_1
XFILLER_9_66 VDD VDD VSS VSS gf180mcu_as_sc_mcu7t3v3__fillcap_4
XFILLER_20_231 VDD VDD VSS VSS gf180mcu_as_sc_mcu7t3v3__fillcap_8
XFILLER_38_139 VDD VDD VSS VSS gf180mcu_as_sc_mcu7t3v3__fillcap_16
XFILLER_34_85 VDD VDD VSS VSS gf180mcu_as_sc_mcu7t3v3__fillcap_16
X_114_ VDD VDD VSS VSS _127_/C _218_/D gf180mcu_as_sc_mcu7t3v3__inv_2
XFILLER_18_64 VDD VDD VSS VSS gf180mcu_as_sc_mcu7t3v3__fillcap_4
XFILLER_18_53 VDD VDD VSS VSS gf180mcu_as_sc_mcu7t3v3__fillcap_4
Xfanout7 VDD VDD VSS VSS _208_/RN _204_/RN gf180mcu_as_sc_mcu7t3v3__buff_2
XFILLER_29_63 VDD VDD VSS VSS gf180mcu_as_sc_mcu7t3v3__fillcap_4
XFILLER_28_172 VDD VDD VSS VSS gf180mcu_as_sc_mcu7t3v3__fill_2
XFILLER_3_260 VDD VDD VSS VSS gf180mcu_as_sc_mcu7t3v3__fillcap_16
XFILLER_3_282 VDD VDD VSS VSS gf180mcu_as_sc_mcu7t3v3__fillcap_8
XFILLER_6_34 VDD VDD VSS VSS gf180mcu_as_sc_mcu7t3v3__fill_1
XFILLER_25_197 VDD VDD VSS VSS gf180mcu_as_sc_mcu7t3v3__fill_1
XFILLER_25_142 VDD VDD VSS VSS gf180mcu_as_sc_mcu7t3v3__fillcap_4
XFILLER_15_76 VDD VDD VSS VSS gf180mcu_as_sc_mcu7t3v3__fill_1
XTAP_TAPCELL_ROW_26_192 VDD VSS gf180mcu_as_sc_mcu7t3v3__tap_2
XTAP_TAPCELL_ROW_18_159 VDD VSS gf180mcu_as_sc_mcu7t3v3__tap_2
XFILLER_0_274 VDD VDD VSS VSS gf180mcu_as_sc_mcu7t3v3__fillcap_16
XFILLER_39_212 VDD VDD VSS VSS gf180mcu_as_sc_mcu7t3v3__fillcap_16
XFILLER_26_20 VDD VDD VSS VSS gf180mcu_as_sc_mcu7t3v3__fill_1
XFILLER_8_171 VDD VDD VSS VSS gf180mcu_as_sc_mcu7t3v3__fillcap_4
XFILLER_8_193 VDD VDD VSS VSS gf180mcu_as_sc_mcu7t3v3__fillcap_16
XFILLER_27_248 VDD VDD VSS VSS gf180mcu_as_sc_mcu7t3v3__fillcap_16
XFILLER_18_226 VDD VDD VSS VSS gf180mcu_as_sc_mcu7t3v3__fillcap_16
XFILLER_10_104 VDD VDD VSS VSS gf180mcu_as_sc_mcu7t3v3__fill_1
XFILLER_10_159 VDD VDD VSS VSS gf180mcu_as_sc_mcu7t3v3__fillcap_4
XTAP_TAPCELL_ROW_34_224 VDD VSS gf180mcu_as_sc_mcu7t3v3__tap_2
XFILLER_5_174 VDD VDD VSS VSS gf180mcu_as_sc_mcu7t3v3__fillcap_16
XTAP_TAPCELL_ROW_11_132 VDD VSS gf180mcu_as_sc_mcu7t3v3__tap_2
XTAP_TAPCELL_ROW_40_249 VDD VSS gf180mcu_as_sc_mcu7t3v3__tap_2
XFILLER_23_251 VDD VDD VSS VSS gf180mcu_as_sc_mcu7t3v3__fillcap_16
XPHY_EDGE_ROW_21_Right_21 VDD VSS gf180mcu_as_sc_mcu7t3v3__tap_2
X_130_ VDD VDD VSS VSS _138_/B _218_/D _218_/Q gf180mcu_as_sc_mcu7t3v3__nor2b_2
XPHY_EDGE_ROW_12_Right_12 VDD VSS gf180mcu_as_sc_mcu7t3v3__tap_2
XPHY_EDGE_ROW_30_Right_30 VDD VSS gf180mcu_as_sc_mcu7t3v3__tap_2
XFILLER_3_2 VDD VDD VSS VSS gf180mcu_as_sc_mcu7t3v3__fillcap_16
XFILLER_2_177 VDD VDD VSS VSS gf180mcu_as_sc_mcu7t3v3__fillcap_16
XFILLER_2_155 VDD VDD VSS VSS gf180mcu_as_sc_mcu7t3v3__fillcap_16
XFILLER_0_36 VDD VDD VSS VSS gf180mcu_as_sc_mcu7t3v3__fillcap_16
XFILLER_9_34 VDD VDD VSS VSS gf180mcu_as_sc_mcu7t3v3__fillcap_16
XFILLER_9_89 VDD VDD VSS VSS gf180mcu_as_sc_mcu7t3v3__fill_2
XFILLER_36_2 VDD VDD VSS VSS gf180mcu_as_sc_mcu7t3v3__fillcap_16
XFILLER_20_287 VDD VDD VSS VSS gf180mcu_as_sc_mcu7t3v3__fillcap_4
XFILLER_20_243 VDD VDD VSS VSS gf180mcu_as_sc_mcu7t3v3__fill_2
XFILLER_34_53 VDD VDD VSS VSS gf180mcu_as_sc_mcu7t3v3__fillcap_16
X_113_ VDD VDD VSS VSS _122_/A _225_/Q gf180mcu_as_sc_mcu7t3v3__inv_2
XFILLER_11_276 VDD VDD VSS VSS gf180mcu_as_sc_mcu7t3v3__fillcap_4
XFILLER_38_107 VDD VDD VSS VSS gf180mcu_as_sc_mcu7t3v3__fillcap_16
XFILLER_6_291 VDD VDD VSS VSS gf180mcu_as_sc_mcu7t3v3__fill_1
XPHY_EDGE_ROW_6_Right_6 VDD VSS gf180mcu_as_sc_mcu7t3v3__tap_2
XTAP_TAPCELL_ROW_26_193 VDD VSS gf180mcu_as_sc_mcu7t3v3__tap_2
XFILLER_26_65 VDD VDD VSS VSS gf180mcu_as_sc_mcu7t3v3__fill_2
XFILLER_9_128 VDD VDD VSS VSS gf180mcu_as_sc_mcu7t3v3__fillcap_8
XFILLER_29_290 VDD VDD VSS VSS gf180mcu_as_sc_mcu7t3v3__fill_2
XFILLER_35_282 VDD VDD VSS VSS gf180mcu_as_sc_mcu7t3v3__fillcap_8
XFILLER_35_260 VDD VDD VSS VSS gf180mcu_as_sc_mcu7t3v3__fillcap_16
XTAP_TAPCELL_ROW_20_166 VDD VSS gf180mcu_as_sc_mcu7t3v3__tap_2
XFILLER_12_34 VDD VDD VSS VSS gf180mcu_as_sc_mcu7t3v3__fill_1
XTAP_TAPCELL_ROW_28_200 VDD VSS gf180mcu_as_sc_mcu7t3v3__tap_2
XTAP_TAPCELL_ROW_11_133 VDD VSS gf180mcu_as_sc_mcu7t3v3__tap_2
XFILLER_5_120 VDD VDD VSS VSS gf180mcu_as_sc_mcu7t3v3__fillcap_16
XFILLER_5_142 VDD VDD VSS VSS gf180mcu_as_sc_mcu7t3v3__fillcap_16
XTAP_TAPCELL_ROW_34_225 VDD VSS gf180mcu_as_sc_mcu7t3v3__tap_2
XFILLER_32_263 VDD VDD VSS VSS gf180mcu_as_sc_mcu7t3v3__fillcap_16
XFILLER_32_241 VDD VDD VSS VSS gf180mcu_as_sc_mcu7t3v3__fillcap_4
XFILLER_17_282 VDD VDD VSS VSS gf180mcu_as_sc_mcu7t3v3__fillcap_8
XFILLER_17_260 VDD VDD VSS VSS gf180mcu_as_sc_mcu7t3v3__fillcap_16
XFILLER_15_208 VDD VDD VSS VSS gf180mcu_as_sc_mcu7t3v3__fill_2
XFILLER_14_263 VDD VDD VSS VSS gf180mcu_as_sc_mcu7t3v3__fillcap_16
XFILLER_2_123 VDD VDD VSS VSS gf180mcu_as_sc_mcu7t3v3__fillcap_16
XFILLER_2_101 VDD VDD VSS VSS gf180mcu_as_sc_mcu7t3v3__fillcap_4
X_189_ VDD VDD VSS VSS _224_/CLK _189_/Q _224_/RN _189_/SN _189_/D gf180mcu_as_sc_mcu7t3v3__dfsrtp_2
XPHY_EDGE_ROW_8_Left_49 VDD VSS gf180mcu_as_sc_mcu7t3v3__tap_2
XFILLER_11_244 VDD VDD VSS VSS gf180mcu_as_sc_mcu7t3v3__fillcap_16
Xload_slew10 VDD VDD VSS VSS _208_/RN _212_/RN gf180mcu_as_sc_mcu7t3v3__buff_8
Xfanout9 VDD VDD VSS VSS _226_/RN _208_/RN gf180mcu_as_sc_mcu7t3v3__buff_2
XFILLER_37_174 VDD VDD VSS VSS gf180mcu_as_sc_mcu7t3v3__fillcap_16
XFILLER_20_34 VDD VDD VSS VSS gf180mcu_as_sc_mcu7t3v3__fill_1
XFILLER_28_174 VDD VDD VSS VSS gf180mcu_as_sc_mcu7t3v3__fill_1
XFILLER_6_69 VDD VDD VSS VSS gf180mcu_as_sc_mcu7t3v3__fillcap_16
XFILLER_34_177 VDD VDD VSS VSS gf180mcu_as_sc_mcu7t3v3__fillcap_16
XFILLER_34_155 VDD VDD VSS VSS gf180mcu_as_sc_mcu7t3v3__fillcap_16
XFILLER_31_88 VDD VDD VSS VSS gf180mcu_as_sc_mcu7t3v3__fillcap_16
XFILLER_31_66 VDD VDD VSS VSS gf180mcu_as_sc_mcu7t3v3__fillcap_4
XFILLER_31_158 VDD VDD VSS VSS gf180mcu_as_sc_mcu7t3v3__fillcap_16
XFILLER_31_136 VDD VDD VSS VSS gf180mcu_as_sc_mcu7t3v3__fillcap_4
XFILLER_22_136 VDD VDD VSS VSS gf180mcu_as_sc_mcu7t3v3__fillcap_16
XFILLER_11_2 VDD VDD VSS VSS gf180mcu_as_sc_mcu7t3v3__fillcap_16
XFILLER_38_291 VDD VDD VSS VSS gf180mcu_as_sc_mcu7t3v3__fill_1
XPHY_EDGE_ROW_37_Left_78 VDD VSS gf180mcu_as_sc_mcu7t3v3__tap_2
Xclkbuf_3_3__f_clk_i VDD VDD VSS VSS clkbuf_0_clk_i/Y _221_/CLK gf180mcu_as_sc_mcu7t3v3__clkbuff_12
XTAP_TAPCELL_ROW_14_142 VDD VSS gf180mcu_as_sc_mcu7t3v3__tap_2
XTAP_TAPCELL_ROW_37_234 VDD VSS gf180mcu_as_sc_mcu7t3v3__tap_2
XTAP_TAPCELL_ROW_20_167 VDD VSS gf180mcu_as_sc_mcu7t3v3__tap_2
XTAP_TAPCELL_ROW_28_201 VDD VSS gf180mcu_as_sc_mcu7t3v3__tap_2
X_219__32 VDD VDD VSS VSS _219_/RN gf180mcu_as_sc_mcu7t3v3__tieh_4
XFILLER_23_275 VDD VDD VSS VSS gf180mcu_as_sc_mcu7t3v3__fillcap_4
X_188_ VDD VDD VSS VSS _225_/CLK _188_/Q _215_/RN _188_/SN _188_/D gf180mcu_as_sc_mcu7t3v3__dfsrtp_2
XPHY_EDGE_ROW_24_Left_65 VDD VSS gf180mcu_as_sc_mcu7t3v3__tap_2
XFILLER_14_242 VDD VDD VSS VSS gf180mcu_as_sc_mcu7t3v3__fill_2
XFILLER_1_190 VDD VDD VSS VSS gf180mcu_as_sc_mcu7t3v3__fillcap_16
X_213__49 VDD VDD VSS VSS _213_/RN gf180mcu_as_sc_mcu7t3v3__tieh_4
XFILLER_18_34 VDD VDD VSS VSS gf180mcu_as_sc_mcu7t3v3__fill_1
XFILLER_9_290 VDD VDD VSS VSS gf180mcu_as_sc_mcu7t3v3__fill_2
XFILLER_11_212 VDD VDD VSS VSS gf180mcu_as_sc_mcu7t3v3__fillcap_16
XFILLER_37_142 VDD VDD VSS VSS gf180mcu_as_sc_mcu7t3v3__fillcap_16
XFILLER_37_120 VDD VDD VSS VSS gf180mcu_as_sc_mcu7t3v3__fillcap_16
XFILLER_29_88 VDD VDD VSS VSS gf180mcu_as_sc_mcu7t3v3__fillcap_16
XFILLER_29_55 VDD VDD VSS VSS gf180mcu_as_sc_mcu7t3v3__fillcap_8
XFILLER_6_37 VDD VDD VSS VSS gf180mcu_as_sc_mcu7t3v3__fillcap_16
XFILLER_34_123 VDD VDD VSS VSS gf180mcu_as_sc_mcu7t3v3__fillcap_16
XFILLER_34_101 VDD VDD VSS VSS gf180mcu_as_sc_mcu7t3v3__fillcap_4
X_189__26 VDD VDD VSS VSS _189_/SN gf180mcu_as_sc_mcu7t3v3__tieh_4
XFILLER_40_104 VDD VDD VSS VSS gf180mcu_as_sc_mcu7t3v3__fillcap_16
XFILLER_31_34 VDD VDD VSS VSS gf180mcu_as_sc_mcu7t3v3__fillcap_16
X_186__29 VDD VDD VSS VSS _186_/SN gf180mcu_as_sc_mcu7t3v3__tieh_4
XFILLER_15_68 VDD VDD VSS VSS gf180mcu_as_sc_mcu7t3v3__fill_2
XFILLER_0_222 VDD VDD VSS VSS gf180mcu_as_sc_mcu7t3v3__fillcap_16
XPHY_EDGE_ROW_11_Left_52 VDD VSS gf180mcu_as_sc_mcu7t3v3__tap_2
XFILLER_31_104 VDD VDD VSS VSS gf180mcu_as_sc_mcu7t3v3__fillcap_16
XFILLER_16_134 VDD VDD VSS VSS gf180mcu_as_sc_mcu7t3v3__fill_2
XFILLER_16_112 VDD VDD VSS VSS gf180mcu_as_sc_mcu7t3v3__fillcap_4
XFILLER_26_67 VDD VDD VSS VSS gf180mcu_as_sc_mcu7t3v3__fill_1
XFILLER_22_159 VDD VDD VSS VSS gf180mcu_as_sc_mcu7t3v3__fill_2
XTAP_TAPCELL_ROW_14_143 VDD VSS gf180mcu_as_sc_mcu7t3v3__tap_2
XFILLER_13_159 VDD VDD VSS VSS gf180mcu_as_sc_mcu7t3v3__fill_2
XTAP_TAPCELL_ROW_37_235 VDD VSS gf180mcu_as_sc_mcu7t3v3__tap_2
XFILLER_10_107 VDD VDD VSS VSS gf180mcu_as_sc_mcu7t3v3__fillcap_4
XFILLER_37_88 VDD VDD VSS VSS gf180mcu_as_sc_mcu7t3v3__fillcap_16
XFILLER_37_66 VDD VDD VSS VSS gf180mcu_as_sc_mcu7t3v3__fillcap_4
XTAP_TAPCELL_ROW_20_168 VDD VSS gf180mcu_as_sc_mcu7t3v3__tap_2
XFILLER_32_287 VDD VDD VSS VSS gf180mcu_as_sc_mcu7t3v3__fillcap_4
X_225__47 VDD VDD VSS VSS _225_/SN gf180mcu_as_sc_mcu7t3v3__tieh_4
X_187_ VDD VDD VSS VSS _212_/CLK _187_/Q _212_/RN _187_/SN _187_/D gf180mcu_as_sc_mcu7t3v3__dfsrtp_2
XFILLER_14_287 VDD VDD VSS VSS gf180mcu_as_sc_mcu7t3v3__fillcap_4
XTAP_TAPCELL_ROW_0_82 VDD VSS gf180mcu_as_sc_mcu7t3v3__tap_2
XFILLER_20_279 VDD VDD VSS VSS gf180mcu_as_sc_mcu7t3v3__fillcap_8
XFILLER_34_34 VDD VDD VSS VSS gf180mcu_as_sc_mcu7t3v3__fill_1
XFILLER_1_2 VDD VDD VSS VSS gf180mcu_as_sc_mcu7t3v3__fillcap_16
XFILLER_7_206 VDD VDD VSS VSS gf180mcu_as_sc_mcu7t3v3__fillcap_4
XFILLER_7_228 VDD VDD VSS VSS gf180mcu_as_sc_mcu7t3v3__fillcap_16
Xclkload0 VDD VDD VSS VSS _205_/CLK clkload0/Y gf180mcu_as_sc_mcu7t3v3__clkbuff_4
XFILLER_34_2 VDD VDD VSS VSS gf180mcu_as_sc_mcu7t3v3__fillcap_16
XFILLER_29_67 VDD VDD VSS VSS gf180mcu_as_sc_mcu7t3v3__fill_2
XFILLER_4_209 VDD VDD VSS VSS gf180mcu_as_sc_mcu7t3v3__fillcap_16
XFILLER_19_165 VDD VDD VSS VSS gf180mcu_as_sc_mcu7t3v3__fillcap_16
XFILLER_40_138 VDD VDD VSS VSS gf180mcu_as_sc_mcu7t3v3__fillcap_16
XFILLER_33_190 VDD VDD VSS VSS gf180mcu_as_sc_mcu7t3v3__fillcap_16
XFILLER_25_102 VDD VDD VSS VSS gf180mcu_as_sc_mcu7t3v3__fill_1
XPHY_EDGE_ROW_28_Right_28 VDD VSS gf180mcu_as_sc_mcu7t3v3__tap_2
XPHY_EDGE_ROW_19_Right_19 VDD VSS gf180mcu_as_sc_mcu7t3v3__tap_2
XFILLER_0_256 VDD VDD VSS VSS gf180mcu_as_sc_mcu7t3v3__fillcap_16
XPHY_EDGE_ROW_37_Right_37 VDD VSS gf180mcu_as_sc_mcu7t3v3__tap_2
XFILLER_30_193 VDD VDD VSS VSS gf180mcu_as_sc_mcu7t3v3__fillcap_16
XFILLER_30_171 VDD VDD VSS VSS gf180mcu_as_sc_mcu7t3v3__fillcap_4
X_185__30 VDD VDD VSS VSS _185_/SN gf180mcu_as_sc_mcu7t3v3__tieh_4
XFILLER_29_282 VDD VDD VSS VSS gf180mcu_as_sc_mcu7t3v3__fillcap_8
XFILLER_29_260 VDD VDD VSS VSS gf180mcu_as_sc_mcu7t3v3__fillcap_16
XFILLER_21_193 VDD VDD VSS VSS gf180mcu_as_sc_mcu7t3v3__fill_2
XFILLER_13_138 VDD VDD VSS VSS gf180mcu_as_sc_mcu7t3v3__fill_2
XTAP_TAPCELL_ROW_8_120 VDD VSS gf180mcu_as_sc_mcu7t3v3__tap_2
XTAP_TAPCELL_ROW_37_236 VDD VSS gf180mcu_as_sc_mcu7t3v3__tap_2
XFILLER_27_208 VDD VDD VSS VSS gf180mcu_as_sc_mcu7t3v3__fill_2
XTAP_TAPCELL_ROW_14_144 VDD VSS gf180mcu_as_sc_mcu7t3v3__tap_2
XFILLER_37_34 VDD VDD VSS VSS gf180mcu_as_sc_mcu7t3v3__fillcap_16
XFILLER_26_263 VDD VDD VSS VSS gf180mcu_as_sc_mcu7t3v3__fillcap_16
XTAP_TAPCELL_ROW_20_169 VDD VSS gf180mcu_as_sc_mcu7t3v3__tap_2
XFILLER_10_119 VDD VDD VSS VSS gf180mcu_as_sc_mcu7t3v3__fill_2
XFILLER_12_37 VDD VDD VSS VSS gf180mcu_as_sc_mcu7t3v3__fillcap_4
XFILLER_23_69 VDD VDD VSS VSS gf180mcu_as_sc_mcu7t3v3__fill_1
XFILLER_23_25 VDD VDD VSS VSS gf180mcu_as_sc_mcu7t3v3__fillcap_4
X_186_ VDD VDD VSS VSS _213_/CLK _186_/Q _215_/RN _186_/SN _186_/D gf180mcu_as_sc_mcu7t3v3__dfsrtp_2
XFILLER_14_244 VDD VDD VSS VSS gf180mcu_as_sc_mcu7t3v3__fill_1
XFILLER_14_222 VDD VDD VSS VSS gf180mcu_as_sc_mcu7t3v3__fillcap_16
XFILLER_0_18 VDD VDD VSS VSS gf180mcu_as_sc_mcu7t3v3__fillcap_16
XFILLER_20_247 VDD VDD VSS VSS gf180mcu_as_sc_mcu7t3v3__fillcap_16
XTAP_TAPCELL_ROW_0_83 VDD VSS gf180mcu_as_sc_mcu7t3v3__tap_2
Xclkload1 VDD VDD VSS VSS _221_/CLK clkload1/Y gf180mcu_as_sc_mcu7t3v3__clkbuff_4
X_169_ VDD VDD VSS VSS _170_/C _171_/A _173_/B gf180mcu_as_sc_mcu7t3v3__or2_2
XFILLER_27_2 VDD VDD VSS VSS gf180mcu_as_sc_mcu7t3v3__fillcap_16
XFILLER_1_72 VDD VDD VSS VSS gf180mcu_as_sc_mcu7t3v3__fillcap_16
XFILLER_1_50 VDD VDD VSS VSS gf180mcu_as_sc_mcu7t3v3__fillcap_16
XFILLER_10_291 VDD VDD VSS VSS gf180mcu_as_sc_mcu7t3v3__fill_1
XFILLER_28_177 VDD VDD VSS VSS gf180mcu_as_sc_mcu7t3v3__fillcap_16
XFILLER_28_100 VDD VDD VSS VSS gf180mcu_as_sc_mcu7t3v3__fill_1
XFILLER_20_37 VDD VDD VSS VSS gf180mcu_as_sc_mcu7t3v3__fillcap_16
X_198__17 VDD VDD VSS VSS _198_/SN gf180mcu_as_sc_mcu7t3v3__tieh_4
XFILLER_3_276 VDD VDD VSS VSS gf180mcu_as_sc_mcu7t3v3__fillcap_4
XFILLER_16_136 VDD VDD VSS VSS gf180mcu_as_sc_mcu7t3v3__fill_1
XFILLER_39_228 VDD VDD VSS VSS gf180mcu_as_sc_mcu7t3v3__fillcap_16
XFILLER_39_206 VDD VDD VSS VSS gf180mcu_as_sc_mcu7t3v3__fillcap_4
XFILLER_26_25 VDD VDD VSS VSS gf180mcu_as_sc_mcu7t3v3__fillcap_4
XTAP_TAPCELL_ROW_23_178 VDD VSS gf180mcu_as_sc_mcu7t3v3__tap_2
XFILLER_3_18 VDD VDD VSS VSS gf180mcu_as_sc_mcu7t3v3__fillcap_16
XTAP_TAPCELL_ROW_8_121 VDD VSS gf180mcu_as_sc_mcu7t3v3__tap_2
XFILLER_36_209 VDD VDD VSS VSS gf180mcu_as_sc_mcu7t3v3__fillcap_16
XFILLER_16_91 VDD VDD VSS VSS gf180mcu_as_sc_mcu7t3v3__fill_2
XTAP_TAPCELL_ROW_14_145 VDD VSS gf180mcu_as_sc_mcu7t3v3__tap_2
XFILLER_12_161 VDD VDD VSS VSS gf180mcu_as_sc_mcu7t3v3__fillcap_8
XTAP_TAPCELL_ROW_37_237 VDD VSS gf180mcu_as_sc_mcu7t3v3__tap_2
XFILLER_23_267 VDD VDD VSS VSS gf180mcu_as_sc_mcu7t3v3__fillcap_8
X_185_ VDD VDD VSS VSS _213_/CLK _185_/Q _212_/RN _185_/SN _185_/D gf180mcu_as_sc_mcu7t3v3__dfsrtp_2
XTAP_TAPCELL_ROW_0_84 VDD VSS gf180mcu_as_sc_mcu7t3v3__tap_2
XFILLER_9_260 VDD VDD VSS VSS gf180mcu_as_sc_mcu7t3v3__fillcap_16
XFILLER_9_282 VDD VDD VSS VSS gf180mcu_as_sc_mcu7t3v3__fillcap_8
X_207__38 VDD VDD VSS VSS _207_/SN gf180mcu_as_sc_mcu7t3v3__tieh_4
XFILLER_34_69 VDD VDD VSS VSS gf180mcu_as_sc_mcu7t3v3__fillcap_16
XFILLER_18_37 VDD VDD VSS VSS gf180mcu_as_sc_mcu7t3v3__fillcap_16
Xclkload2 VDD VDD VSS VSS _212_/CLK clkload2/Y gf180mcu_as_sc_mcu7t3v3__clkbuff_4
XPHY_EDGE_ROW_28_Left_69 VDD VSS gf180mcu_as_sc_mcu7t3v3__tap_2
XFILLER_24_91 VDD VDD VSS VSS gf180mcu_as_sc_mcu7t3v3__fill_1
X_168_ VDD VDD VSS VSS _171_/B _174_/B _225_/Q gf180mcu_as_sc_mcu7t3v3__nand2_2
XFILLER_6_241 VDD VDD VSS VSS gf180mcu_as_sc_mcu7t3v3__fillcap_4
XFILLER_6_263 VDD VDD VSS VSS gf180mcu_as_sc_mcu7t3v3__fillcap_16
XFILLER_29_69 VDD VDD VSS VSS gf180mcu_as_sc_mcu7t3v3__fill_1
Xclkbuf_3_6__f_clk_i VDD VDD VSS VSS clkbuf_0_clk_i/Y _225_/CLK gf180mcu_as_sc_mcu7t3v3__clkbuff_12
XFILLER_19_189 VDD VDD VSS VSS gf180mcu_as_sc_mcu7t3v3__fillcap_4
XFILLER_19_112 VDD VDD VSS VSS gf180mcu_as_sc_mcu7t3v3__fill_1
XFILLER_3_244 VDD VDD VSS VSS gf180mcu_as_sc_mcu7t3v3__fillcap_16
XFILLER_6_18 VDD VDD VSS VSS gf180mcu_as_sc_mcu7t3v3__fillcap_16
X_194__21 VDD VDD VSS VSS _194_/SN gf180mcu_as_sc_mcu7t3v3__tieh_4
XPHY_EDGE_ROW_1_Right_1 VDD VSS gf180mcu_as_sc_mcu7t3v3__tap_2
XTAP_TAPCELL_ROW_17_154 VDD VSS gf180mcu_as_sc_mcu7t3v3__tap_2
XFILLER_15_170 VDD VDD VSS VSS gf180mcu_as_sc_mcu7t3v3__fillcap_8
XFILLER_7_50 VDD VDD VSS VSS gf180mcu_as_sc_mcu7t3v3__fillcap_16
XFILLER_7_72 VDD VDD VSS VSS gf180mcu_as_sc_mcu7t3v3__fillcap_16
X_191__24 VDD VDD VSS VSS _191_/SN gf180mcu_as_sc_mcu7t3v3__tieh_4
XFILLER_26_37 VDD VDD VSS VSS gf180mcu_as_sc_mcu7t3v3__fill_2
XTAP_TAPCELL_ROW_23_179 VDD VSS gf180mcu_as_sc_mcu7t3v3__tap_2
XPHY_EDGE_ROW_15_Left_56 VDD VSS gf180mcu_as_sc_mcu7t3v3__tap_2
XFILLER_8_155 VDD VDD VSS VSS gf180mcu_as_sc_mcu7t3v3__fillcap_16
XFILLER_8_177 VDD VDD VSS VSS gf180mcu_as_sc_mcu7t3v3__fillcap_16
XFILLER_12_173 VDD VDD VSS VSS gf180mcu_as_sc_mcu7t3v3__fill_2
XFILLER_35_276 VDD VDD VSS VSS gf180mcu_as_sc_mcu7t3v3__fillcap_4
XFILLER_26_287 VDD VDD VSS VSS gf180mcu_as_sc_mcu7t3v3__fillcap_4
XFILLER_5_136 VDD VDD VSS VSS gf180mcu_as_sc_mcu7t3v3__fillcap_4
XFILLER_5_158 VDD VDD VSS VSS gf180mcu_as_sc_mcu7t3v3__fillcap_16
XFILLER_40_290 VDD VDD VSS VSS gf180mcu_as_sc_mcu7t3v3__fill_2
XFILLER_32_279 VDD VDD VSS VSS gf180mcu_as_sc_mcu7t3v3__fillcap_8
XFILLER_17_276 VDD VDD VSS VSS gf180mcu_as_sc_mcu7t3v3__fillcap_4
XFILLER_31_290 VDD VDD VSS VSS gf180mcu_as_sc_mcu7t3v3__fill_2
XFILLER_23_279 VDD VDD VSS VSS gf180mcu_as_sc_mcu7t3v3__fill_1
XFILLER_23_235 VDD VDD VSS VSS gf180mcu_as_sc_mcu7t3v3__fillcap_16
XFILLER_14_279 VDD VDD VSS VSS gf180mcu_as_sc_mcu7t3v3__fillcap_8
XFILLER_2_139 VDD VDD VSS VSS gf180mcu_as_sc_mcu7t3v3__fillcap_16
XFILLER_9_18 VDD VDD VSS VSS gf180mcu_as_sc_mcu7t3v3__fillcap_16
XFILLER_13_290 VDD VDD VSS VSS gf180mcu_as_sc_mcu7t3v3__fill_2
XTAP_TAPCELL_ROW_0_85 VDD VSS gf180mcu_as_sc_mcu7t3v3__tap_2
X_184_ VDD VDD VSS VSS _213_/CLK _184_/Q _212_/RN _184_/SN _184_/D gf180mcu_as_sc_mcu7t3v3__dfsrtp_2
XFILLER_34_37 VDD VDD VSS VSS gf180mcu_as_sc_mcu7t3v3__fillcap_16
Xclkload3 VDD VDD VSS VSS _225_/CLK clkload3/Y gf180mcu_as_sc_mcu7t3v3__clkbuff_4
XFILLER_11_205 VDD VDD VSS VSS gf180mcu_as_sc_mcu7t3v3__fillcap_4
X_167_ VDD VDD VSS VSS _214_/Q _221_/Q _213_/Q _170_/C gf180mcu_as_sc_mcu7t3v3__nor3_2
XPHY_EDGE_ROW_3_Left_44 VDD VSS gf180mcu_as_sc_mcu7t3v3__tap_2
X_203__42 VDD VDD VSS VSS _203_/SN gf180mcu_as_sc_mcu7t3v3__tieh_4
XFILLER_28_135 VDD VDD VSS VSS gf180mcu_as_sc_mcu7t3v3__fillcap_8
XFILLER_3_212 VDD VDD VSS VSS gf180mcu_as_sc_mcu7t3v3__fillcap_16
XFILLER_32_2 VDD VDD VSS VSS gf180mcu_as_sc_mcu7t3v3__fillcap_16
XFILLER_19_92 VDD VDD VSS VSS gf180mcu_as_sc_mcu7t3v3__fill_1
X_219_ VDD VDD VSS VSS _219_/CLK _220_/D _219_/RN _224_/RN cio_csb_i gf180mcu_as_sc_mcu7t3v3__dfsrtp_2
XFILLER_24_171 VDD VDD VSS VSS gf180mcu_as_sc_mcu7t3v3__fillcap_4
XTAP_TAPCELL_ROW_17_155 VDD VSS gf180mcu_as_sc_mcu7t3v3__tap_2
XFILLER_38_263 VDD VDD VSS VSS gf180mcu_as_sc_mcu7t3v3__fillcap_16
XFILLER_38_241 VDD VDD VSS VSS gf180mcu_as_sc_mcu7t3v3__fillcap_4
XPHY_EDGE_ROW_24_Right_24 VDD VSS gf180mcu_as_sc_mcu7t3v3__tap_2
XPHY_EDGE_ROW_15_Right_15 VDD VSS gf180mcu_as_sc_mcu7t3v3__tap_2
XPHY_EDGE_ROW_33_Right_33 VDD VSS gf180mcu_as_sc_mcu7t3v3__tap_2
XPHY_EDGE_ROW_32_Left_73 VDD VSS gf180mcu_as_sc_mcu7t3v3__tap_2
XFILLER_8_101 VDD VDD VSS VSS gf180mcu_as_sc_mcu7t3v3__fillcap_4
XFILLER_8_123 VDD VDD VSS VSS gf180mcu_as_sc_mcu7t3v3__fillcap_16
XFILLER_35_244 VDD VDD VSS VSS gf180mcu_as_sc_mcu7t3v3__fillcap_16
XFILLER_12_18 VDD VDD VSS VSS gf180mcu_as_sc_mcu7t3v3__fillcap_16
XFILLER_5_104 VDD VDD VSS VSS gf180mcu_as_sc_mcu7t3v3__fillcap_16
XFILLER_32_247 VDD VDD VSS VSS gf180mcu_as_sc_mcu7t3v3__fillcap_16
XFILLER_32_225 VDD VDD VSS VSS gf180mcu_as_sc_mcu7t3v3__fillcap_16
XFILLER_27_92 VDD VDD VSS VSS gf180mcu_as_sc_mcu7t3v3__fill_2
XFILLER_17_244 VDD VDD VSS VSS gf180mcu_as_sc_mcu7t3v3__fillcap_16
XFILLER_4_85 VDD VDD VSS VSS gf180mcu_as_sc_mcu7t3v3__fillcap_16
XTAP_TAPCELL_ROW_33_220 VDD VSS gf180mcu_as_sc_mcu7t3v3__tap_2
XFILLER_2_107 VDD VDD VSS VSS gf180mcu_as_sc_mcu7t3v3__fillcap_16
XFILLER_22_291 VDD VDD VSS VSS gf180mcu_as_sc_mcu7t3v3__fill_1
X_215__51 VDD VDD VSS VSS _215_/SN gf180mcu_as_sc_mcu7t3v3__tieh_4
X_183_ VDD VDD VSS VSS _183_/B _212_/Q _212_/D gf180mcu_as_sc_mcu7t3v3__and2_2
XFILLER_14_247 VDD VDD VSS VSS gf180mcu_as_sc_mcu7t3v3__fillcap_16
XTAP_TAPCELL_ROW_0_86 VDD VSS gf180mcu_as_sc_mcu7t3v3__tap_2
XFILLER_20_239 VDD VDD VSS VSS gf180mcu_as_sc_mcu7t3v3__fillcap_4
XFILLER_11_228 VDD VDD VSS VSS gf180mcu_as_sc_mcu7t3v3__fillcap_16
Xclkload4 VDD VDD VSS VSS _226_/CLK clkload4/Y gf180mcu_as_sc_mcu7t3v3__clkbuff_4
XFILLER_40_70 VDD VDD VSS VSS gf180mcu_as_sc_mcu7t3v3__fillcap_16
XFILLER_37_158 VDD VDD VSS VSS gf180mcu_as_sc_mcu7t3v3__fillcap_16
XFILLER_37_136 VDD VDD VSS VSS gf180mcu_as_sc_mcu7t3v3__fillcap_4
XFILLER_20_18 VDD VDD VSS VSS gf180mcu_as_sc_mcu7t3v3__fillcap_16
X_166_ VDD VDD VSS VSS _166_/S _211_/Q _202_/Q _202_/D gf180mcu_as_sc_mcu7t3v3__mux2_2
XFILLER_6_287 VDD VDD VSS VSS gf180mcu_as_sc_mcu7t3v3__fillcap_4
XFILLER_34_139 VDD VDD VSS VSS gf180mcu_as_sc_mcu7t3v3__fillcap_16
X_218_ VDD VDD VSS VSS _221_/CLK _218_/Q _221_/SN _218_/SN _218_/D gf180mcu_as_sc_mcu7t3v3__dfsrtp_2
X_149_ VDD VDD VSS VSS _187_/Q _149_/B _166_/S _212_/Q _150_/D gf180mcu_as_sc_mcu7t3v3__ao22_2
XFILLER_25_2 VDD VDD VSS VSS gf180mcu_as_sc_mcu7t3v3__fillcap_16
XFILLER_26_39 VDD VDD VSS VSS gf180mcu_as_sc_mcu7t3v3__fill_1
XTAP_TAPCELL_ROW_17_156 VDD VSS gf180mcu_as_sc_mcu7t3v3__tap_2
XFILLER_21_142 VDD VDD VSS VSS gf180mcu_as_sc_mcu7t3v3__fill_2
XFILLER_35_212 VDD VDD VSS VSS gf180mcu_as_sc_mcu7t3v3__fillcap_16
XFILLER_7_190 VDD VDD VSS VSS gf180mcu_as_sc_mcu7t3v3__fillcap_16
Xload_slew3 VDD VDD VSS VSS _217_/RN _224_/RN gf180mcu_as_sc_mcu7t3v3__buff_8
XFILLER_17_212 VDD VDD VSS VSS gf180mcu_as_sc_mcu7t3v3__fillcap_16
XFILLER_4_171 VDD VDD VSS VSS gf180mcu_as_sc_mcu7t3v3__fillcap_4
XFILLER_4_193 VDD VDD VSS VSS gf180mcu_as_sc_mcu7t3v3__fillcap_16
XTAP_TAPCELL_ROW_33_221 VDD VSS gf180mcu_as_sc_mcu7t3v3__tap_2
XFILLER_23_29 VDD VDD VSS VSS gf180mcu_as_sc_mcu7t3v3__fill_2
XFILLER_23_18 VDD VDD VSS VSS gf180mcu_as_sc_mcu7t3v3__fill_2
XFILLER_4_53 VDD VDD VSS VSS gf180mcu_as_sc_mcu7t3v3__fillcap_16
X_182_ VDD VDD VSS VSS _183_/B _211_/Q _211_/D gf180mcu_as_sc_mcu7t3v3__and2_2
XTAP_TAPCELL_ROW_0_87 VDD VSS gf180mcu_as_sc_mcu7t3v3__tap_2
XFILLER_1_174 VDD VDD VSS VSS gf180mcu_as_sc_mcu7t3v3__fillcap_16
X_221__44 VDD VDD VSS VSS _221_/RN gf180mcu_as_sc_mcu7t3v3__tieh_4
XFILLER_18_18 VDD VDD VSS VSS gf180mcu_as_sc_mcu7t3v3__fillcap_16
XFILLER_37_104 VDD VDD VSS VSS gf180mcu_as_sc_mcu7t3v3__fillcap_16
X_165_ VDD VDD VSS VSS _166_/S _210_/Q _201_/Q _201_/D gf180mcu_as_sc_mcu7t3v3__mux2_2
XFILLER_29_39 VDD VDD VSS VSS gf180mcu_as_sc_mcu7t3v3__fillcap_16
XFILLER_34_107 VDD VDD VSS VSS gf180mcu_as_sc_mcu7t3v3__fillcap_16
X_217_ VDD VDD VSS VSS _224_/CLK _218_/D _217_/RN _217_/SN _217_/D gf180mcu_as_sc_mcu7t3v3__dfsrtp_2
XFILLER_19_72 VDD VDD VSS VSS gf180mcu_as_sc_mcu7t3v3__fillcap_16
X_148_ VDD VDD VSS VSS _150_/C _148_/B _148_/A gf180mcu_as_sc_mcu7t3v3__nor2b_2
XFILLER_10_96 VDD VDD VSS VSS gf180mcu_as_sc_mcu7t3v3__fillcap_8
XFILLER_31_18 VDD VDD VSS VSS gf180mcu_as_sc_mcu7t3v3__fillcap_16
XFILLER_18_192 VDD VDD VSS VSS gf180mcu_as_sc_mcu7t3v3__fill_1
XFILLER_18_2 VDD VDD VSS VSS gf180mcu_as_sc_mcu7t3v3__fillcap_16
XFILLER_2_291 VDD VDD VSS VSS gf180mcu_as_sc_mcu7t3v3__fill_1
XFILLER_0_206 VDD VDD VSS VSS gf180mcu_as_sc_mcu7t3v3__fillcap_16
XFILLER_24_195 VDD VDD VSS VSS gf180mcu_as_sc_mcu7t3v3__fill_1
XFILLER_16_107 VDD VDD VSS VSS gf180mcu_as_sc_mcu7t3v3__fill_1
XTAP_TAPCELL_ROW_17_157 VDD VSS gf180mcu_as_sc_mcu7t3v3__tap_2
XFILLER_38_287 VDD VDD VSS VSS gf180mcu_as_sc_mcu7t3v3__fillcap_4
XFILLER_29_276 VDD VDD VSS VSS gf180mcu_as_sc_mcu7t3v3__fillcap_4
XFILLER_26_18 VDD VDD VSS VSS gf180mcu_as_sc_mcu7t3v3__fill_2
XFILLER_26_29 VDD VDD VSS VSS gf180mcu_as_sc_mcu7t3v3__fill_2
XPHY_EDGE_ROW_5_Right_5 VDD VSS gf180mcu_as_sc_mcu7t3v3__tap_2
XTAP_TAPCELL_ROW_3_98 VDD VSS gf180mcu_as_sc_mcu7t3v3__tap_2
XTAP_TAPCELL_ROW_36_230 VDD VSS gf180mcu_as_sc_mcu7t3v3__tap_2
XFILLER_26_279 VDD VDD VSS VSS gf180mcu_as_sc_mcu7t3v3__fillcap_8
XTAP_TAPCELL_ROW_5_106 VDD VSS gf180mcu_as_sc_mcu7t3v3__tap_2
XFILLER_27_72 VDD VDD VSS VSS gf180mcu_as_sc_mcu7t3v3__fill_1
XFILLER_25_290 VDD VDD VSS VSS gf180mcu_as_sc_mcu7t3v3__fill_2
XFILLER_17_202 VDD VDD VSS VSS gf180mcu_as_sc_mcu7t3v3__fillcap_8
XFILLER_31_282 VDD VDD VSS VSS gf180mcu_as_sc_mcu7t3v3__fillcap_8
XFILLER_31_260 VDD VDD VSS VSS gf180mcu_as_sc_mcu7t3v3__fillcap_16
XFILLER_14_238 VDD VDD VSS VSS gf180mcu_as_sc_mcu7t3v3__fillcap_4
X_181_ VDD VDD VSS VSS _183_/B _210_/Q _210_/D gf180mcu_as_sc_mcu7t3v3__and2_2
XFILLER_13_30 VDD VDD VSS VSS gf180mcu_as_sc_mcu7t3v3__fill_2
XFILLER_1_142 VDD VDD VSS VSS gf180mcu_as_sc_mcu7t3v3__fillcap_16
XFILLER_1_120 VDD VDD VSS VSS gf180mcu_as_sc_mcu7t3v3__fillcap_16
XFILLER_13_282 VDD VDD VSS VSS gf180mcu_as_sc_mcu7t3v3__fillcap_8
XTAP_TAPCELL_ROW_0_88 VDD VSS gf180mcu_as_sc_mcu7t3v3__tap_2
XFILLER_34_18 VDD VDD VSS VSS gf180mcu_as_sc_mcu7t3v3__fillcap_16
XFILLER_39_190 VDD VDD VSS VSS gf180mcu_as_sc_mcu7t3v3__fillcap_16
X_164_ VDD VDD VSS VSS _166_/S _209_/Q _200_/Q _200_/D gf180mcu_as_sc_mcu7t3v3__mux2_2
XFILLER_1_88 VDD VDD VSS VSS gf180mcu_as_sc_mcu7t3v3__fillcap_16
XFILLER_1_66 VDD VDD VSS VSS gf180mcu_as_sc_mcu7t3v3__fillcap_4
XFILLER_10_241 VDD VDD VSS VSS gf180mcu_as_sc_mcu7t3v3__fillcap_4
XFILLER_10_263 VDD VDD VSS VSS gf180mcu_as_sc_mcu7t3v3__fillcap_16
XFILLER_36_193 VDD VDD VSS VSS gf180mcu_as_sc_mcu7t3v3__fillcap_16
XFILLER_36_171 VDD VDD VSS VSS gf180mcu_as_sc_mcu7t3v3__fillcap_4
XFILLER_35_72 VDD VDD VSS VSS gf180mcu_as_sc_mcu7t3v3__fillcap_16
XFILLER_35_50 VDD VDD VSS VSS gf180mcu_as_sc_mcu7t3v3__fillcap_16
XFILLER_19_149 VDD VDD VSS VSS gf180mcu_as_sc_mcu7t3v3__fillcap_16
X_200__15 VDD VDD VSS VSS _200_/SN gf180mcu_as_sc_mcu7t3v3__tieh_4
XFILLER_19_105 VDD VDD VSS VSS gf180mcu_as_sc_mcu7t3v3__fill_2
XPHY_EDGE_ROW_7_Left_48 VDD VSS gf180mcu_as_sc_mcu7t3v3__tap_2
XFILLER_10_53 VDD VDD VSS VSS gf180mcu_as_sc_mcu7t3v3__fillcap_4
XFILLER_33_174 VDD VDD VSS VSS gf180mcu_as_sc_mcu7t3v3__fillcap_16
X_147_ VDD VDD VSS VSS _147_/A _147_/B _186_/Q _147_/D _150_/B gf180mcu_as_sc_mcu7t3v3__ao211_2
X_216_ VDD VDD VSS VSS _219_/CLK _217_/D _224_/RN _216_/SN cio_sck_i gf180mcu_as_sc_mcu7t3v3__dfsrtp_2
XFILLER_24_185 VDD VDD VSS VSS gf180mcu_as_sc_mcu7t3v3__fill_1
XFILLER_24_163 VDD VDD VSS VSS gf180mcu_as_sc_mcu7t3v3__fillcap_8
XFILLER_21_30 VDD VDD VSS VSS gf180mcu_as_sc_mcu7t3v3__fill_2
XFILLER_30_177 VDD VDD VSS VSS gf180mcu_as_sc_mcu7t3v3__fillcap_16
XFILLER_30_155 VDD VDD VSS VSS gf180mcu_as_sc_mcu7t3v3__fillcap_16
XFILLER_30_2 VDD VDD VSS VSS gf180mcu_as_sc_mcu7t3v3__fillcap_16
XFILLER_21_144 VDD VDD VSS VSS gf180mcu_as_sc_mcu7t3v3__fill_1
XFILLER_29_244 VDD VDD VSS VSS gf180mcu_as_sc_mcu7t3v3__fillcap_16
XPHY_EDGE_ROW_20_Right_20 VDD VSS gf180mcu_as_sc_mcu7t3v3__tap_2
XPHY_EDGE_ROW_11_Right_11 VDD VSS gf180mcu_as_sc_mcu7t3v3__tap_2
XTAP_TAPCELL_ROW_3_99 VDD VSS gf180mcu_as_sc_mcu7t3v3__tap_2
XFILLER_12_177 VDD VDD VSS VSS gf180mcu_as_sc_mcu7t3v3__fill_2
XFILLER_37_18 VDD VDD VSS VSS gf180mcu_as_sc_mcu7t3v3__fillcap_16
XTAP_TAPCELL_ROW_36_231 VDD VSS gf180mcu_as_sc_mcu7t3v3__tap_2
XFILLER_26_247 VDD VDD VSS VSS gf180mcu_as_sc_mcu7t3v3__fillcap_16
XTAP_TAPCELL_ROW_5_107 VDD VSS gf180mcu_as_sc_mcu7t3v3__tap_2
XPHY_EDGE_ROW_36_Left_77 VDD VSS gf180mcu_as_sc_mcu7t3v3__tap_2
XFILLER_34_291 VDD VDD VSS VSS gf180mcu_as_sc_mcu7t3v3__fill_1
XFILLER_16_291 VDD VDD VSS VSS gf180mcu_as_sc_mcu7t3v3__fill_1
X_180_ VDD VDD VSS VSS _183_/B _209_/Q _209_/D gf180mcu_as_sc_mcu7t3v3__and2_2
XFILLER_13_97 VDD VDD VSS VSS gf180mcu_as_sc_mcu7t3v3__fill_2
XFILLER_13_250 VDD VDD VSS VSS gf180mcu_as_sc_mcu7t3v3__fillcap_16
XTAP_TAPCELL_ROW_0_89 VDD VSS gf180mcu_as_sc_mcu7t3v3__tap_2
XFILLER_8_2 VDD VDD VSS VSS gf180mcu_as_sc_mcu7t3v3__fillcap_16
XFILLER_9_276 VDD VDD VSS VSS gf180mcu_as_sc_mcu7t3v3__fillcap_4
XFILLER_11_209 VDD VDD VSS VSS gf180mcu_as_sc_mcu7t3v3__fill_1
XPHY_EDGE_ROW_39_Left_80 VDD VSS gf180mcu_as_sc_mcu7t3v3__tap_2
X_163_ VDD VDD VSS VSS _166_/S _208_/Q _199_/Q _199_/D gf180mcu_as_sc_mcu7t3v3__mux2_2
XFILLER_6_279 VDD VDD VSS VSS gf180mcu_as_sc_mcu7t3v3__fillcap_8
XPHY_EDGE_ROW_23_Left_64 VDD VSS gf180mcu_as_sc_mcu7t3v3__tap_2
XFILLER_1_34 VDD VDD VSS VSS gf180mcu_as_sc_mcu7t3v3__fillcap_16
XFILLER_5_290 VDD VDD VSS VSS gf180mcu_as_sc_mcu7t3v3__fill_2
XFILLER_27_194 VDD VDD VSS VSS gf180mcu_as_sc_mcu7t3v3__fillcap_4
XFILLER_19_30 VDD VDD VSS VSS gf180mcu_as_sc_mcu7t3v3__fill_2
XFILLER_33_142 VDD VDD VSS VSS gf180mcu_as_sc_mcu7t3v3__fillcap_16
XFILLER_33_120 VDD VDD VSS VSS gf180mcu_as_sc_mcu7t3v3__fillcap_16
X_215_ VDD VDD VSS VSS _225_/CLK _215_/Q _215_/RN _215_/SN _215_/D gf180mcu_as_sc_mcu7t3v3__dfsrtp_2
X_146_ VDD VDD VSS VSS _147_/B _185_/Q _146_/B _146_/C _184_/Q gf180mcu_as_sc_mcu7t3v3__aoi22_2
XFILLER_30_123 VDD VDD VSS VSS gf180mcu_as_sc_mcu7t3v3__fillcap_16
XFILLER_30_101 VDD VDD VSS VSS gf180mcu_as_sc_mcu7t3v3__fillcap_4
XFILLER_15_142 VDD VDD VSS VSS gf180mcu_as_sc_mcu7t3v3__fill_1
XFILLER_7_66 VDD VDD VSS VSS gf180mcu_as_sc_mcu7t3v3__fillcap_4
XFILLER_7_88 VDD VDD VSS VSS gf180mcu_as_sc_mcu7t3v3__fillcap_16
XFILLER_23_2 VDD VDD VSS VSS gf180mcu_as_sc_mcu7t3v3__fillcap_16
X_129_ VDD VDD VSS VSS cio_sd_o _221_/Q _187_/Q gf180mcu_as_sc_mcu7t3v3__nor2b_2
XPHY_EDGE_ROW_10_Left_51 VDD VSS gf180mcu_as_sc_mcu7t3v3__tap_2
XFILLER_32_85 VDD VDD VSS VSS gf180mcu_as_sc_mcu7t3v3__fillcap_16
XFILLER_29_212 VDD VDD VSS VSS gf180mcu_as_sc_mcu7t3v3__fillcap_16
XFILLER_16_97 VDD VDD VSS VSS gf180mcu_as_sc_mcu7t3v3__fillcap_8
XTAP_TAPCELL_ROW_13_140 VDD VSS gf180mcu_as_sc_mcu7t3v3__tap_2
XTAP_TAPCELL_ROW_5_108 VDD VSS gf180mcu_as_sc_mcu7t3v3__tap_2
XTAP_TAPCELL_ROW_36_232 VDD VSS gf180mcu_as_sc_mcu7t3v3__tap_2
XFILLER_40_240 VDD VDD VSS VSS gf180mcu_as_sc_mcu7t3v3__fillcap_16
Xload_slew6 VDD VDD VSS VSS _197_/RN _211_/RN gf180mcu_as_sc_mcu7t3v3__buff_8
XFILLER_4_34 VDD VDD VSS VSS gf180mcu_as_sc_mcu7t3v3__fill_1
Xfanout11 VDD VDD VSS VSS rst_ni _226_/RN gf180mcu_as_sc_mcu7t3v3__buff_2
XFILLER_13_32 VDD VDD VSS VSS gf180mcu_as_sc_mcu7t3v3__fill_1
XFILLER_9_244 VDD VDD VSS VSS gf180mcu_as_sc_mcu7t3v3__fillcap_16
Xclkbuf_0_clk_i VDD VDD VSS VSS clk_i clkbuf_0_clk_i/Y gf180mcu_as_sc_mcu7t3v3__clkbuff_12
XFILLER_40_52 VDD VDD VSS VSS gf180mcu_as_sc_mcu7t3v3__fillcap_16
XFILLER_24_53 VDD VDD VSS VSS gf180mcu_as_sc_mcu7t3v3__fill_1
XFILLER_6_225 VDD VDD VSS VSS gf180mcu_as_sc_mcu7t3v3__fillcap_16
XFILLER_6_247 VDD VDD VSS VSS gf180mcu_as_sc_mcu7t3v3__fillcap_16
X_162_ VDD VDD VSS VSS _166_/S _207_/Q _198_/Q _198_/D gf180mcu_as_sc_mcu7t3v3__mux2_2
XFILLER_10_287 VDD VDD VSS VSS gf180mcu_as_sc_mcu7t3v3__fillcap_4
XPHY_EDGE_ROW_40_Left_81 VDD VSS gf180mcu_as_sc_mcu7t3v3__tap_2
XFILLER_28_107 VDD VDD VSS VSS gf180mcu_as_sc_mcu7t3v3__fillcap_8
XFILLER_19_107 VDD VDD VSS VSS gf180mcu_as_sc_mcu7t3v3__fill_1
XFILLER_3_206 VDD VDD VSS VSS gf180mcu_as_sc_mcu7t3v3__fillcap_4
XFILLER_3_228 VDD VDD VSS VSS gf180mcu_as_sc_mcu7t3v3__fillcap_16
X_214_ VDD VDD VSS VSS _226_/CLK _214_/Q _226_/RN _214_/SN _214_/D gf180mcu_as_sc_mcu7t3v3__dfsrtp_2
XFILLER_19_97 VDD VDD VSS VSS gf180mcu_as_sc_mcu7t3v3__fillcap_8
X_145_ VDD VDD VSS VSS _145_/B _202_/Q _147_/A gf180mcu_as_sc_mcu7t3v3__or2_2
XFILLER_18_184 VDD VDD VSS VSS gf180mcu_as_sc_mcu7t3v3__fillcap_8
XFILLER_21_32 VDD VDD VSS VSS gf180mcu_as_sc_mcu7t3v3__fill_1
XFILLER_15_154 VDD VDD VSS VSS gf180mcu_as_sc_mcu7t3v3__fillcap_16
XFILLER_38_279 VDD VDD VSS VSS gf180mcu_as_sc_mcu7t3v3__fillcap_8
X_128_ VDD VDD VSS VSS _159_/B _148_/B _225_/D gf180mcu_as_sc_mcu7t3v3__and2_2
XFILLER_21_135 VDD VDD VSS VSS gf180mcu_as_sc_mcu7t3v3__fillcap_4
XFILLER_16_2 VDD VDD VSS VSS gf180mcu_as_sc_mcu7t3v3__fillcap_16
XFILLER_7_34 VDD VDD VSS VSS gf180mcu_as_sc_mcu7t3v3__fillcap_16
XFILLER_37_290 VDD VDD VSS VSS gf180mcu_as_sc_mcu7t3v3__fill_2
XFILLER_32_53 VDD VDD VSS VSS gf180mcu_as_sc_mcu7t3v3__fillcap_16
XTAP_TAPCELL_ROW_22_174 VDD VSS gf180mcu_as_sc_mcu7t3v3__tap_2
XFILLER_16_87 VDD VDD VSS VSS gf180mcu_as_sc_mcu7t3v3__fillcap_4
XFILLER_8_139 VDD VDD VSS VSS gf180mcu_as_sc_mcu7t3v3__fillcap_16
XTAP_TAPCELL_ROW_13_141 VDD VSS gf180mcu_as_sc_mcu7t3v3__tap_2
XPHY_EDGE_ROW_9_Right_9 VDD VSS gf180mcu_as_sc_mcu7t3v3__tap_2
XTAP_TAPCELL_ROW_36_233 VDD VSS gf180mcu_as_sc_mcu7t3v3__tap_2
XFILLER_19_290 VDD VDD VSS VSS gf180mcu_as_sc_mcu7t3v3__fill_2
XTAP_TAPCELL_ROW_5_109 VDD VSS gf180mcu_as_sc_mcu7t3v3__tap_2
XFILLER_40_274 VDD VDD VSS VSS gf180mcu_as_sc_mcu7t3v3__fillcap_16
XFILLER_25_282 VDD VDD VSS VSS gf180mcu_as_sc_mcu7t3v3__fillcap_8
X_224__12 VDD VDD VSS VSS _224_/SN gf180mcu_as_sc_mcu7t3v3__tieh_4
XFILLER_23_219 VDD VDD VSS VSS gf180mcu_as_sc_mcu7t3v3__fillcap_16
XFILLER_38_85 VDD VDD VSS VSS gf180mcu_as_sc_mcu7t3v3__fillcap_16
XFILLER_22_263 VDD VDD VSS VSS gf180mcu_as_sc_mcu7t3v3__fillcap_16
XTAP_TAPCELL_ROW_30_206 VDD VSS gf180mcu_as_sc_mcu7t3v3__tap_2
XFILLER_13_274 VDD VDD VSS VSS gf180mcu_as_sc_mcu7t3v3__fillcap_4
XFILLER_9_212 VDD VDD VSS VSS gf180mcu_as_sc_mcu7t3v3__fillcap_16
X_212__48 VDD VDD VSS VSS _212_/SN gf180mcu_as_sc_mcu7t3v3__tieh_4
X_161_ VDD VDD VSS VSS _166_/S _206_/Q _197_/Q _197_/D gf180mcu_as_sc_mcu7t3v3__mux2_2
XFILLER_40_86 VDD VDD VSS VSS gf180mcu_as_sc_mcu7t3v3__fillcap_16
XFILLER_28_119 VDD VDD VSS VSS gf180mcu_as_sc_mcu7t3v3__fillcap_16
XTAP_TAPCELL_ROW_1_90 VDD VSS gf180mcu_as_sc_mcu7t3v3__tap_2
XFILLER_10_34 VDD VDD VSS VSS gf180mcu_as_sc_mcu7t3v3__fill_1
X_213_ VDD VDD VSS VSS _213_/CLK _213_/Q _213_/RN _215_/RN _213_/D gf180mcu_as_sc_mcu7t3v3__dfsrtp_2
XFILLER_19_32 VDD VDD VSS VSS gf180mcu_as_sc_mcu7t3v3__fill_1
X_144_ VDD VDD VSS VSS _144_/A _144_/B _144_/C _150_/A gf180mcu_as_sc_mcu7t3v3__nand3_2
Xclkbuf_3_2__f_clk_i VDD VDD VSS VSS clkbuf_0_clk_i/Y _224_/CLK gf180mcu_as_sc_mcu7t3v3__clkbuff_12
XFILLER_24_177 VDD VDD VSS VSS gf180mcu_as_sc_mcu7t3v3__fillcap_8
XFILLER_38_247 VDD VDD VSS VSS gf180mcu_as_sc_mcu7t3v3__fillcap_16
XFILLER_38_225 VDD VDD VSS VSS gf180mcu_as_sc_mcu7t3v3__fillcap_16
X_127_ VDD VDD VSS VSS _213_/D _218_/Q _127_/C _159_/B gf180mcu_as_sc_mcu7t3v3__nor3_2
XTAP_TAPCELL_ROW_16_150 VDD VSS gf180mcu_as_sc_mcu7t3v3__tap_2
XTAP_TAPCELL_ROW_39_242 VDD VSS gf180mcu_as_sc_mcu7t3v3__tap_2
XTAP_TAPCELL_ROW_8_118 VDD VSS gf180mcu_as_sc_mcu7t3v3__tap_2
XFILLER_8_107 VDD VDD VSS VSS gf180mcu_as_sc_mcu7t3v3__fillcap_16
XFILLER_12_169 VDD VDD VSS VSS gf180mcu_as_sc_mcu7t3v3__fillcap_4
XFILLER_35_228 VDD VDD VSS VSS gf180mcu_as_sc_mcu7t3v3__fillcap_16
XFILLER_35_206 VDD VDD VSS VSS gf180mcu_as_sc_mcu7t3v3__fillcap_4
XFILLER_28_291 VDD VDD VSS VSS gf180mcu_as_sc_mcu7t3v3__fill_1
XTAP_TAPCELL_ROW_22_175 VDD VSS gf180mcu_as_sc_mcu7t3v3__tap_2
XFILLER_32_209 VDD VDD VSS VSS gf180mcu_as_sc_mcu7t3v3__fillcap_16
Xload_slew8 VDD VDD VSS VSS _204_/RN _215_/RN gf180mcu_as_sc_mcu7t3v3__buff_8
X_218__54 VDD VDD VSS VSS _218_/SN gf180mcu_as_sc_mcu7t3v3__tieh_4
XFILLER_17_228 VDD VDD VSS VSS gf180mcu_as_sc_mcu7t3v3__fillcap_16
XFILLER_4_69 VDD VDD VSS VSS gf180mcu_as_sc_mcu7t3v3__fillcap_16
XFILLER_38_53 VDD VDD VSS VSS gf180mcu_as_sc_mcu7t3v3__fillcap_16
XTAP_TAPCELL_ROW_30_207 VDD VSS gf180mcu_as_sc_mcu7t3v3__tap_2
XFILLER_6_2 VDD VDD VSS VSS gf180mcu_as_sc_mcu7t3v3__fillcap_16
X_160_ VDD VDD VSS VSS _166_/S _205_/Q _196_/Q _196_/D gf180mcu_as_sc_mcu7t3v3__mux2_2
XFILLER_39_2 VDD VDD VSS VSS gf180mcu_as_sc_mcu7t3v3__fillcap_16
XPHY_EDGE_ROW_27_Right_27 VDD VSS gf180mcu_as_sc_mcu7t3v3__tap_2
XPHY_EDGE_ROW_18_Right_18 VDD VSS gf180mcu_as_sc_mcu7t3v3__tap_2
XTAP_TAPCELL_ROW_1_91 VDD VSS gf180mcu_as_sc_mcu7t3v3__tap_2
XFILLER_5_260 VDD VDD VSS VSS gf180mcu_as_sc_mcu7t3v3__fillcap_16
XFILLER_5_282 VDD VDD VSS VSS gf180mcu_as_sc_mcu7t3v3__fillcap_8
XPHY_EDGE_ROW_36_Right_36 VDD VSS gf180mcu_as_sc_mcu7t3v3__tap_2
XFILLER_27_142 VDD VDD VSS VSS gf180mcu_as_sc_mcu7t3v3__fill_1
XFILLER_19_88 VDD VDD VSS VSS gf180mcu_as_sc_mcu7t3v3__fillcap_4
X_212_ VDD VDD VSS VSS _212_/CLK _212_/Q _212_/RN _212_/SN _212_/D gf180mcu_as_sc_mcu7t3v3__dfsrtp_2
X_143_ VDD VDD VSS VSS _144_/C _199_/Q _147_/D _143_/C _198_/Q gf180mcu_as_sc_mcu7t3v3__aoi22_2
XFILLER_10_57 VDD VDD VSS VSS gf180mcu_as_sc_mcu7t3v3__fill_2
XPHY_EDGE_ROW_27_Left_68 VDD VSS gf180mcu_as_sc_mcu7t3v3__tap_2
XFILLER_18_197 VDD VDD VSS VSS gf180mcu_as_sc_mcu7t3v3__fill_2
XFILLER_2_263 VDD VDD VSS VSS gf180mcu_as_sc_mcu7t3v3__fillcap_16
XFILLER_2_241 VDD VDD VSS VSS gf180mcu_as_sc_mcu7t3v3__fillcap_4
X_126_ VDD VDD VSS VSS _147_/D _186_/Q _148_/B gf180mcu_as_sc_mcu7t3v3__and2_2
XFILLER_15_178 VDD VDD VSS VSS gf180mcu_as_sc_mcu7t3v3__fill_1
XTAP_TAPCELL_ROW_39_243 VDD VSS gf180mcu_as_sc_mcu7t3v3__tap_2
XTAP_TAPCELL_ROW_16_151 VDD VSS gf180mcu_as_sc_mcu7t3v3__tap_2
XFILLER_16_34 VDD VDD VSS VSS gf180mcu_as_sc_mcu7t3v3__fill_1
XTAP_TAPCELL_ROW_8_119 VDD VSS gf180mcu_as_sc_mcu7t3v3__tap_2
XTAP_TAPCELL_ROW_22_176 VDD VSS gf180mcu_as_sc_mcu7t3v3__tap_2
XPHY_EDGE_ROW_0_Right_0 VDD VSS gf180mcu_as_sc_mcu7t3v3__tap_2
XFILLER_12_104 VDD VDD VSS VSS gf180mcu_as_sc_mcu7t3v3__fill_1
XFILLER_21_2 VDD VDD VSS VSS gf180mcu_as_sc_mcu7t3v3__fillcap_16
XPHY_EDGE_ROW_14_Left_55 VDD VSS gf180mcu_as_sc_mcu7t3v3__tap_2
XFILLER_7_174 VDD VDD VSS VSS gf180mcu_as_sc_mcu7t3v3__fillcap_16
XFILLER_27_88 VDD VDD VSS VSS gf180mcu_as_sc_mcu7t3v3__fillcap_4
XFILLER_27_55 VDD VDD VSS VSS gf180mcu_as_sc_mcu7t3v3__fillcap_4
XFILLER_25_273 VDD VDD VSS VSS gf180mcu_as_sc_mcu7t3v3__fillcap_4
XFILLER_31_276 VDD VDD VSS VSS gf180mcu_as_sc_mcu7t3v3__fillcap_4
XFILLER_4_37 VDD VDD VSS VSS gf180mcu_as_sc_mcu7t3v3__fillcap_16
XFILLER_4_155 VDD VDD VSS VSS gf180mcu_as_sc_mcu7t3v3__fillcap_16
XFILLER_4_177 VDD VDD VSS VSS gf180mcu_as_sc_mcu7t3v3__fillcap_16
XFILLER_22_287 VDD VDD VSS VSS gf180mcu_as_sc_mcu7t3v3__fillcap_4
XFILLER_1_158 VDD VDD VSS VSS gf180mcu_as_sc_mcu7t3v3__fillcap_16
XFILLER_1_136 VDD VDD VSS VSS gf180mcu_as_sc_mcu7t3v3__fillcap_4
XTAP_TAPCELL_ROW_30_208 VDD VSS gf180mcu_as_sc_mcu7t3v3__tap_2
XFILLER_8_291 VDD VDD VSS VSS gf180mcu_as_sc_mcu7t3v3__fill_1
XFILLER_24_34 VDD VDD VSS VSS gf180mcu_as_sc_mcu7t3v3__fill_1
XFILLER_10_279 VDD VDD VSS VSS gf180mcu_as_sc_mcu7t3v3__fillcap_8
XTAP_TAPCELL_ROW_1_92 VDD VSS gf180mcu_as_sc_mcu7t3v3__tap_2
XFILLER_35_88 VDD VDD VSS VSS gf180mcu_as_sc_mcu7t3v3__fillcap_16
XFILLER_35_66 VDD VDD VSS VSS gf180mcu_as_sc_mcu7t3v3__fillcap_4
XFILLER_27_198 VDD VDD VSS VSS gf180mcu_as_sc_mcu7t3v3__fill_2
X_142_ VDD VDD VSS VSS _147_/D _186_/Q _144_/B gf180mcu_as_sc_mcu7t3v3__xor2_2
X_211_ VDD VDD VSS VSS _219_/CLK _211_/Q _211_/RN _211_/SN _211_/D gf180mcu_as_sc_mcu7t3v3__dfsrtp_2
X_188__27 VDD VDD VSS VSS _188_/SN gf180mcu_as_sc_mcu7t3v3__tieh_4
XFILLER_18_165 VDD VDD VSS VSS gf180mcu_as_sc_mcu7t3v3__fillcap_4
XPHY_EDGE_ROW_2_Left_43 VDD VSS gf180mcu_as_sc_mcu7t3v3__tap_2
X_125_ VDD VDD VSS VSS _185_/Q _184_/Q _147_/D gf180mcu_as_sc_mcu7t3v3__and2_2
XFILLER_21_127 VDD VDD VSS VSS gf180mcu_as_sc_mcu7t3v3__fillcap_4
XTAP_TAPCELL_ROW_16_152 VDD VSS gf180mcu_as_sc_mcu7t3v3__tap_2
XTAP_TAPCELL_ROW_39_244 VDD VSS gf180mcu_as_sc_mcu7t3v3__tap_2
XFILLER_37_282 VDD VDD VSS VSS gf180mcu_as_sc_mcu7t3v3__fillcap_8
XFILLER_37_260 VDD VDD VSS VSS gf180mcu_as_sc_mcu7t3v3__fillcap_16
XFILLER_32_34 VDD VDD VSS VSS gf180mcu_as_sc_mcu7t3v3__fill_1
XTAP_TAPCELL_ROW_22_177 VDD VSS gf180mcu_as_sc_mcu7t3v3__tap_2
XFILLER_34_241 VDD VDD VSS VSS gf180mcu_as_sc_mcu7t3v3__fillcap_4
XFILLER_19_282 VDD VDD VSS VSS gf180mcu_as_sc_mcu7t3v3__fillcap_8
XFILLER_14_2 VDD VDD VSS VSS gf180mcu_as_sc_mcu7t3v3__fillcap_16
XFILLER_7_120 VDD VDD VSS VSS gf180mcu_as_sc_mcu7t3v3__fillcap_16
XFILLER_7_142 VDD VDD VSS VSS gf180mcu_as_sc_mcu7t3v3__fillcap_16
XFILLER_40_222 VDD VDD VSS VSS gf180mcu_as_sc_mcu7t3v3__fillcap_16
XFILLER_34_263 VDD VDD VSS VSS gf180mcu_as_sc_mcu7t3v3__fillcap_16
XFILLER_31_244 VDD VDD VSS VSS gf180mcu_as_sc_mcu7t3v3__fillcap_16
XPHY_EDGE_ROW_31_Left_72 VDD VSS gf180mcu_as_sc_mcu7t3v3__tap_2
XFILLER_16_263 VDD VDD VSS VSS gf180mcu_as_sc_mcu7t3v3__fillcap_16
XFILLER_16_230 VDD VDD VSS VSS gf180mcu_as_sc_mcu7t3v3__fillcap_8
XFILLER_4_101 VDD VDD VSS VSS gf180mcu_as_sc_mcu7t3v3__fillcap_4
XFILLER_4_123 VDD VDD VSS VSS gf180mcu_as_sc_mcu7t3v3__fillcap_16
XTAP_TAPCELL_ROW_30_209 VDD VSS gf180mcu_as_sc_mcu7t3v3__tap_2
XFILLER_13_266 VDD VDD VSS VSS gf180mcu_as_sc_mcu7t3v3__fillcap_8
XFILLER_1_104 VDD VDD VSS VSS gf180mcu_as_sc_mcu7t3v3__fillcap_16
XFILLER_39_174 VDD VDD VSS VSS gf180mcu_as_sc_mcu7t3v3__fillcap_16
XFILLER_10_225 VDD VDD VSS VSS gf180mcu_as_sc_mcu7t3v3__fillcap_16
XFILLER_10_247 VDD VDD VSS VSS gf180mcu_as_sc_mcu7t3v3__fillcap_16
XTAP_TAPCELL_ROW_1_93 VDD VSS gf180mcu_as_sc_mcu7t3v3__tap_2
XFILLER_36_177 VDD VDD VSS VSS gf180mcu_as_sc_mcu7t3v3__fillcap_16
XFILLER_36_155 VDD VDD VSS VSS gf180mcu_as_sc_mcu7t3v3__fillcap_16
XFILLER_35_34 VDD VDD VSS VSS gf180mcu_as_sc_mcu7t3v3__fillcap_16
XFILLER_10_37 VDD VDD VSS VSS gf180mcu_as_sc_mcu7t3v3__fillcap_16
XFILLER_33_158 VDD VDD VSS VSS gf180mcu_as_sc_mcu7t3v3__fillcap_16
XFILLER_33_136 VDD VDD VSS VSS gf180mcu_as_sc_mcu7t3v3__fillcap_4
XFILLER_18_199 VDD VDD VSS VSS gf180mcu_as_sc_mcu7t3v3__fill_1
X_141_ VDD VDD VSS VSS _144_/A _141_/B _145_/B gf180mcu_as_sc_mcu7t3v3__nand2_2
X_210_ VDD VDD VSS VSS _219_/CLK _210_/Q _211_/RN _210_/SN _210_/D gf180mcu_as_sc_mcu7t3v3__dfsrtp_2
XFILLER_2_287 VDD VDD VSS VSS gf180mcu_as_sc_mcu7t3v3__fillcap_4
XFILLER_24_103 VDD VDD VSS VSS gf180mcu_as_sc_mcu7t3v3__fill_2
XFILLER_30_139 VDD VDD VSS VSS gf180mcu_as_sc_mcu7t3v3__fillcap_16
XTAP_TAPCELL_ROW_25_186 VDD VSS gf180mcu_as_sc_mcu7t3v3__tap_2
X_124_ VDD VDD VSS VSS _214_/D _124_/A _171_/A _226_/D gf180mcu_as_sc_mcu7t3v3__ao21_2
XFILLER_15_114 VDD VDD VSS VSS gf180mcu_as_sc_mcu7t3v3__fill_1
XFILLER_21_139 VDD VDD VSS VSS gf180mcu_as_sc_mcu7t3v3__fill_1
XTAP_TAPCELL_ROW_16_153 VDD VSS gf180mcu_as_sc_mcu7t3v3__tap_2
X_184__31 VDD VDD VSS VSS _184_/SN gf180mcu_as_sc_mcu7t3v3__tieh_4
XTAP_TAPCELL_ROW_39_245 VDD VSS gf180mcu_as_sc_mcu7t3v3__tap_2
XFILLER_29_228 VDD VDD VSS VSS gf180mcu_as_sc_mcu7t3v3__fillcap_16
XFILLER_29_206 VDD VDD VSS VSS gf180mcu_as_sc_mcu7t3v3__fillcap_4
XFILLER_27_68 VDD VDD VSS VSS gf180mcu_as_sc_mcu7t3v3__fill_2
XTAP_TAPCELL_ROW_4_102 VDD VSS gf180mcu_as_sc_mcu7t3v3__tap_2
XFILLER_40_256 VDD VDD VSS VSS gf180mcu_as_sc_mcu7t3v3__fillcap_16
XFILLER_16_242 VDD VDD VSS VSS gf180mcu_as_sc_mcu7t3v3__fill_2
XTAP_TAPCELL_ROW_10_126 VDD VSS gf180mcu_as_sc_mcu7t3v3__tap_2
XTAP_TAPCELL_ROW_33_218 VDD VSS gf180mcu_as_sc_mcu7t3v3__tap_2
XFILLER_31_212 VDD VDD VSS VSS gf180mcu_as_sc_mcu7t3v3__fillcap_16
XFILLER_3_190 VDD VDD VSS VSS gf180mcu_as_sc_mcu7t3v3__fillcap_16
XFILLER_38_34 VDD VDD VSS VSS gf180mcu_as_sc_mcu7t3v3__fill_1
XFILLER_13_278 VDD VDD VSS VSS gf180mcu_as_sc_mcu7t3v3__fill_2
XFILLER_13_234 VDD VDD VSS VSS gf180mcu_as_sc_mcu7t3v3__fillcap_16
XFILLER_13_26 VDD VDD VSS VSS gf180mcu_as_sc_mcu7t3v3__fillcap_4
Xclkbuf_3_5__f_clk_i VDD VDD VSS VSS clkbuf_0_clk_i/Y _212_/CLK gf180mcu_as_sc_mcu7t3v3__clkbuff_12
XFILLER_39_142 VDD VDD VSS VSS gf180mcu_as_sc_mcu7t3v3__fillcap_16
XFILLER_39_120 VDD VDD VSS VSS gf180mcu_as_sc_mcu7t3v3__fillcap_16
XFILLER_1_18 VDD VDD VSS VSS gf180mcu_as_sc_mcu7t3v3__fillcap_16
XFILLER_36_123 VDD VDD VSS VSS gf180mcu_as_sc_mcu7t3v3__fillcap_16
XFILLER_36_101 VDD VDD VSS VSS gf180mcu_as_sc_mcu7t3v3__fillcap_4
X_197__18 VDD VDD VSS VSS _197_/SN gf180mcu_as_sc_mcu7t3v3__tieh_4
XFILLER_27_156 VDD VDD VSS VSS gf180mcu_as_sc_mcu7t3v3__fill_1
XPHY_EDGE_ROW_23_Right_23 VDD VSS gf180mcu_as_sc_mcu7t3v3__tap_2
XPHY_EDGE_ROW_14_Right_14 VDD VSS gf180mcu_as_sc_mcu7t3v3__tap_2
XFILLER_4_2 VDD VDD VSS VSS gf180mcu_as_sc_mcu7t3v3__fillcap_16
X_140_ VDD VDD VSS VSS _184_/Q _197_/Q _196_/Q _141_/B gf180mcu_as_sc_mcu7t3v3__mux2_2
XFILLER_37_2 VDD VDD VSS VSS gf180mcu_as_sc_mcu7t3v3__fillcap_16
XFILLER_33_104 VDD VDD VSS VSS gf180mcu_as_sc_mcu7t3v3__fillcap_16
XPHY_EDGE_ROW_32_Right_32 VDD VSS gf180mcu_as_sc_mcu7t3v3__tap_2
XTAP_TAPCELL_ROW_19_162 VDD VSS gf180mcu_as_sc_mcu7t3v3__tap_2
XFILLER_30_107 VDD VDD VSS VSS gf180mcu_as_sc_mcu7t3v3__fillcap_16
XTAP_TAPCELL_ROW_25_187 VDD VSS gf180mcu_as_sc_mcu7t3v3__tap_2
XFILLER_21_26 VDD VDD VSS VSS gf180mcu_as_sc_mcu7t3v3__fillcap_4
X_123_ VDD VDD VSS VSS _171_/A _213_/D _214_/Q gf180mcu_as_sc_mcu7t3v3__nor2b_2
XFILLER_32_69 VDD VDD VSS VSS gf180mcu_as_sc_mcu7t3v3__fillcap_16
XFILLER_16_37 VDD VDD VSS VSS gf180mcu_as_sc_mcu7t3v3__fill_1
XFILLER_12_107 VDD VDD VSS VSS gf180mcu_as_sc_mcu7t3v3__fill_1
XFILLER_34_287 VDD VDD VSS VSS gf180mcu_as_sc_mcu7t3v3__fillcap_4
XTAP_TAPCELL_ROW_4_103 VDD VSS gf180mcu_as_sc_mcu7t3v3__tap_2
XPHY_EDGE_ROW_4_Right_4 VDD VSS gf180mcu_as_sc_mcu7t3v3__tap_2
XFILLER_25_265 VDD VDD VSS VSS gf180mcu_as_sc_mcu7t3v3__fillcap_8
XFILLER_4_18 VDD VDD VSS VSS gf180mcu_as_sc_mcu7t3v3__fillcap_16
XTAP_TAPCELL_ROW_10_127 VDD VSS gf180mcu_as_sc_mcu7t3v3__tap_2
XTAP_TAPCELL_ROW_33_219 VDD VSS gf180mcu_as_sc_mcu7t3v3__tap_2
X_209__36 VDD VDD VSS VSS _209_/SN gf180mcu_as_sc_mcu7t3v3__tieh_4
XPHY_EDGE_ROW_18_Left_59 VDD VSS gf180mcu_as_sc_mcu7t3v3__tap_2
XFILLER_16_287 VDD VDD VSS VSS gf180mcu_as_sc_mcu7t3v3__fillcap_4
XFILLER_22_279 VDD VDD VSS VSS gf180mcu_as_sc_mcu7t3v3__fillcap_8
XFILLER_22_213 VDD VDD VSS VSS gf180mcu_as_sc_mcu7t3v3__fillcap_16
XFILLER_21_290 VDD VDD VSS VSS gf180mcu_as_sc_mcu7t3v3__fill_2
X_214__50 VDD VDD VSS VSS _214_/SN gf180mcu_as_sc_mcu7t3v3__tieh_4
X_206__39 VDD VDD VSS VSS _206_/SN gf180mcu_as_sc_mcu7t3v3__tieh_4
XFILLER_0_172 VDD VDD VSS VSS gf180mcu_as_sc_mcu7t3v3__fillcap_16
XFILLER_9_228 VDD VDD VSS VSS gf180mcu_as_sc_mcu7t3v3__fillcap_16
XFILLER_40_36 VDD VDD VSS VSS gf180mcu_as_sc_mcu7t3v3__fillcap_16
XFILLER_24_37 VDD VDD VSS VSS gf180mcu_as_sc_mcu7t3v3__fillcap_16
XFILLER_5_50 VDD VDD VSS VSS gf180mcu_as_sc_mcu7t3v3__fillcap_16
XFILLER_5_72 VDD VDD VSS VSS gf180mcu_as_sc_mcu7t3v3__fillcap_16
XFILLER_6_209 VDD VDD VSS VSS gf180mcu_as_sc_mcu7t3v3__fillcap_16
XFILLER_35_190 VDD VDD VSS VSS gf180mcu_as_sc_mcu7t3v3__fillcap_16
XFILLER_27_135 VDD VDD VSS VSS gf180mcu_as_sc_mcu7t3v3__fillcap_4
XFILLER_19_26 VDD VDD VSS VSS gf180mcu_as_sc_mcu7t3v3__fillcap_4
XFILLER_18_157 VDD VDD VSS VSS gf180mcu_as_sc_mcu7t3v3__fillcap_8
X_199_ VDD VDD VSS VSS _212_/CLK _199_/Q _212_/RN _199_/SN _199_/D gf180mcu_as_sc_mcu7t3v3__dfsrtp_2
XFILLER_32_193 VDD VDD VSS VSS gf180mcu_as_sc_mcu7t3v3__fillcap_16
XFILLER_32_171 VDD VDD VSS VSS gf180mcu_as_sc_mcu7t3v3__fillcap_4
X_193__22 VDD VDD VSS VSS _193_/SN gf180mcu_as_sc_mcu7t3v3__tieh_4
XTAP_TAPCELL_ROW_19_163 VDD VSS gf180mcu_as_sc_mcu7t3v3__tap_2
XFILLER_17_190 VDD VDD VSS VSS gf180mcu_as_sc_mcu7t3v3__fill_2
XPHY_EDGE_ROW_6_Left_47 VDD VSS gf180mcu_as_sc_mcu7t3v3__tap_2
XTAP_TAPCELL_ROW_25_188 VDD VSS gf180mcu_as_sc_mcu7t3v3__tap_2
X_122_ VDD VDD VSS VSS _174_/B _122_/A _124_/A gf180mcu_as_sc_mcu7t3v3__or2_2
XFILLER_7_18 VDD VDD VSS VSS gf180mcu_as_sc_mcu7t3v3__fillcap_16
XFILLER_32_37 VDD VDD VSS VSS gf180mcu_as_sc_mcu7t3v3__fillcap_16
X_190__25 VDD VDD VSS VSS _190_/SN gf180mcu_as_sc_mcu7t3v3__tieh_4
XFILLER_21_119 VDD VDD VSS VSS gf180mcu_as_sc_mcu7t3v3__fillcap_8
XFILLER_28_263 VDD VDD VSS VSS gf180mcu_as_sc_mcu7t3v3__fillcap_16
XFILLER_28_241 VDD VDD VSS VSS gf180mcu_as_sc_mcu7t3v3__fillcap_4
XFILLER_27_59 VDD VDD VSS VSS gf180mcu_as_sc_mcu7t3v3__fill_1
XFILLER_25_277 VDD VDD VSS VSS gf180mcu_as_sc_mcu7t3v3__fill_2
XTAP_TAPCELL_ROW_4_104 VDD VSS gf180mcu_as_sc_mcu7t3v3__tap_2
XTAP_TAPCELL_ROW_10_128 VDD VSS gf180mcu_as_sc_mcu7t3v3__tap_2
XFILLER_16_244 VDD VDD VSS VSS gf180mcu_as_sc_mcu7t3v3__fill_1
XFILLER_17_92 VDD VDD VSS VSS gf180mcu_as_sc_mcu7t3v3__fillcap_4
XPHY_EDGE_ROW_9_Left_50 VDD VSS gf180mcu_as_sc_mcu7t3v3__tap_2
XFILLER_38_69 VDD VDD VSS VSS gf180mcu_as_sc_mcu7t3v3__fillcap_16
XFILLER_30_291 VDD VDD VSS VSS gf180mcu_as_sc_mcu7t3v3__fill_1
XFILLER_22_247 VDD VDD VSS VSS gf180mcu_as_sc_mcu7t3v3__fillcap_16
XFILLER_12_2 VDD VDD VSS VSS gf180mcu_as_sc_mcu7t3v3__fillcap_16
XPHY_EDGE_ROW_35_Left_76 VDD VSS gf180mcu_as_sc_mcu7t3v3__tap_2
XFILLER_9_207 VDD VDD VSS VSS gf180mcu_as_sc_mcu7t3v3__fill_2
XFILLER_12_291 VDD VDD VSS VSS gf180mcu_as_sc_mcu7t3v3__fill_1
X_205__40 VDD VDD VSS VSS _205_/SN gf180mcu_as_sc_mcu7t3v3__tieh_4
XFILLER_5_276 VDD VDD VSS VSS gf180mcu_as_sc_mcu7t3v3__fillcap_4
XFILLER_10_18 VDD VDD VSS VSS gf180mcu_as_sc_mcu7t3v3__fillcap_16
XFILLER_18_169 VDD VDD VSS VSS gf180mcu_as_sc_mcu7t3v3__fill_2
XFILLER_2_279 VDD VDD VSS VSS gf180mcu_as_sc_mcu7t3v3__fillcap_8
X_198_ VDD VDD VSS VSS _212_/CLK _198_/Q _212_/RN _198_/SN _198_/D gf180mcu_as_sc_mcu7t3v3__dfsrtp_2
XPHY_EDGE_ROW_22_Left_63 VDD VSS gf180mcu_as_sc_mcu7t3v3__tap_2
XTAP_TAPCELL_ROW_19_164 VDD VSS gf180mcu_as_sc_mcu7t3v3__tap_2
XFILLER_2_85 VDD VDD VSS VSS gf180mcu_as_sc_mcu7t3v3__fillcap_16
XFILLER_1_290 VDD VDD VSS VSS gf180mcu_as_sc_mcu7t3v3__fill_2
XFILLER_38_209 VDD VDD VSS VSS gf180mcu_as_sc_mcu7t3v3__fillcap_16
XTAP_TAPCELL_ROW_25_189 VDD VSS gf180mcu_as_sc_mcu7t3v3__tap_2
X_121_ VDD VDD VSS VSS _174_/B _203_/Q _204_/Q gf180mcu_as_sc_mcu7t3v3__nand2_2
XFILLER_23_150 VDD VDD VSS VSS gf180mcu_as_sc_mcu7t3v3__fillcap_16
XFILLER_11_50 VDD VDD VSS VSS gf180mcu_as_sc_mcu7t3v3__fillcap_4
XFILLER_11_72 VDD VDD VSS VSS gf180mcu_as_sc_mcu7t3v3__fill_2
XTAP_TAPCELL_ROW_21_170 VDD VSS gf180mcu_as_sc_mcu7t3v3__tap_2
XFILLER_19_264 VDD VDD VSS VSS gf180mcu_as_sc_mcu7t3v3__fillcap_16
XFILLER_11_131 VDD VDD VSS VSS gf180mcu_as_sc_mcu7t3v3__fillcap_8
XFILLER_11_142 VDD VDD VSS VSS gf180mcu_as_sc_mcu7t3v3__fill_1
XTAP_TAPCELL_ROW_4_105 VDD VSS gf180mcu_as_sc_mcu7t3v3__tap_2
XTAP_TAPCELL_ROW_10_129 VDD VSS gf180mcu_as_sc_mcu7t3v3__tap_2
XFILLER_13_18 VDD VDD VSS VSS gf180mcu_as_sc_mcu7t3v3__fillcap_8
XFILLER_38_37 VDD VDD VSS VSS gf180mcu_as_sc_mcu7t3v3__fillcap_16
X_220__33 VDD VDD VSS VSS _220_/RN gf180mcu_as_sc_mcu7t3v3__tieh_4
XFILLER_8_241 VDD VDD VSS VSS gf180mcu_as_sc_mcu7t3v3__fillcap_4
XFILLER_8_263 VDD VDD VSS VSS gf180mcu_as_sc_mcu7t3v3__fillcap_16
XFILLER_5_244 VDD VDD VSS VSS gf180mcu_as_sc_mcu7t3v3__fillcap_16
XTAP_TAPCELL_ROW_28_198 VDD VSS gf180mcu_as_sc_mcu7t3v3__tap_2
XFILLER_2_247 VDD VDD VSS VSS gf180mcu_as_sc_mcu7t3v3__fillcap_16
XFILLER_2_225 VDD VDD VSS VSS gf180mcu_as_sc_mcu7t3v3__fillcap_16
X_197_ VDD VDD VSS VSS _205_/CLK _197_/Q _197_/RN _197_/SN _197_/D gf180mcu_as_sc_mcu7t3v3__dfsrtp_2
XFILLER_24_107 VDD VDD VSS VSS gf180mcu_as_sc_mcu7t3v3__fillcap_8
XFILLER_21_18 VDD VDD VSS VSS gf180mcu_as_sc_mcu7t3v3__fillcap_8
XTAP_TAPCELL_ROW_19_165 VDD VSS gf180mcu_as_sc_mcu7t3v3__tap_2
XFILLER_2_53 VDD VDD VSS VSS gf180mcu_as_sc_mcu7t3v3__fillcap_16
XPHY_EDGE_ROW_10_Right_10 VDD VSS gf180mcu_as_sc_mcu7t3v3__tap_2
X_120_ VDD VDD VSS VSS _213_/D _122_/A _120_/C _226_/D gf180mcu_as_sc_mcu7t3v3__nor3_2
XFILLER_2_2 VDD VDD VSS VSS gf180mcu_as_sc_mcu7t3v3__fillcap_16
XFILLER_35_2 VDD VDD VSS VSS gf180mcu_as_sc_mcu7t3v3__fillcap_16
XFILLER_14_195 VDD VDD VSS VSS gf180mcu_as_sc_mcu7t3v3__fill_2
XFILLER_14_140 VDD VDD VSS VSS gf180mcu_as_sc_mcu7t3v3__fill_1
XFILLER_37_276 VDD VDD VSS VSS gf180mcu_as_sc_mcu7t3v3__fillcap_4
XFILLER_20_187 VDD VDD VSS VSS gf180mcu_as_sc_mcu7t3v3__fill_2
XFILLER_16_18 VDD VDD VSS VSS gf180mcu_as_sc_mcu7t3v3__fillcap_16
XTAP_TAPCELL_ROW_7_114 VDD VSS gf180mcu_as_sc_mcu7t3v3__tap_2
XFILLER_28_287 VDD VDD VSS VSS gf180mcu_as_sc_mcu7t3v3__fillcap_4
XTAP_TAPCELL_ROW_21_171 VDD VSS gf180mcu_as_sc_mcu7t3v3__tap_2
XFILLER_19_232 VDD VDD VSS VSS gf180mcu_as_sc_mcu7t3v3__fillcap_16
XTAP_TAPCELL_ROW_13_138 VDD VSS gf180mcu_as_sc_mcu7t3v3__tap_2
XFILLER_7_136 VDD VDD VSS VSS gf180mcu_as_sc_mcu7t3v3__fillcap_4
XFILLER_7_158 VDD VDD VSS VSS gf180mcu_as_sc_mcu7t3v3__fillcap_16
XFILLER_34_279 VDD VDD VSS VSS gf180mcu_as_sc_mcu7t3v3__fillcap_8
XFILLER_33_290 VDD VDD VSS VSS gf180mcu_as_sc_mcu7t3v3__fill_2
XFILLER_25_279 VDD VDD VSS VSS gf180mcu_as_sc_mcu7t3v3__fill_1
XFILLER_8_85 VDD VDD VSS VSS gf180mcu_as_sc_mcu7t3v3__fillcap_16
XFILLER_16_279 VDD VDD VSS VSS gf180mcu_as_sc_mcu7t3v3__fillcap_8
XFILLER_4_139 VDD VDD VSS VSS gf180mcu_as_sc_mcu7t3v3__fillcap_16
XFILLER_15_290 VDD VDD VSS VSS gf180mcu_as_sc_mcu7t3v3__fill_2
XPHY_EDGE_ROW_8_Right_8 VDD VSS gf180mcu_as_sc_mcu7t3v3__tap_2
XPHY_EDGE_ROW_39_Right_39 VDD VSS gf180mcu_as_sc_mcu7t3v3__tap_2
XFILLER_21_282 VDD VDD VSS VSS gf180mcu_as_sc_mcu7t3v3__fillcap_8
XFILLER_9_209 VDD VDD VSS VSS gf180mcu_as_sc_mcu7t3v3__fill_1
XFILLER_28_82 VDD VDD VSS VSS gf180mcu_as_sc_mcu7t3v3__fill_1
XFILLER_0_120 VDD VDD VSS VSS gf180mcu_as_sc_mcu7t3v3__fillcap_16
XFILLER_24_18 VDD VDD VSS VSS gf180mcu_as_sc_mcu7t3v3__fillcap_16
X_211__34 VDD VDD VSS VSS _211_/SN gf180mcu_as_sc_mcu7t3v3__tieh_4
XFILLER_29_190 VDD VDD VSS VSS gf180mcu_as_sc_mcu7t3v3__fillcap_16
XFILLER_5_212 VDD VDD VSS VSS gf180mcu_as_sc_mcu7t3v3__fillcap_16
XFILLER_19_18 VDD VDD VSS VSS gf180mcu_as_sc_mcu7t3v3__fillcap_8
XTAP_TAPCELL_ROW_28_199 VDD VSS gf180mcu_as_sc_mcu7t3v3__tap_2
XFILLER_25_72 VDD VDD VSS VSS gf180mcu_as_sc_mcu7t3v3__fillcap_4
X_196_ VDD VDD VSS VSS _205_/CLK _196_/Q _197_/RN _196_/SN _196_/D gf180mcu_as_sc_mcu7t3v3__dfsrtp_2
XFILLER_23_174 VDD VDD VSS VSS gf180mcu_as_sc_mcu7t3v3__fillcap_4
X_179_ VDD VDD VSS VSS _183_/B _208_/Q _208_/D gf180mcu_as_sc_mcu7t3v3__and2_2
XFILLER_14_174 VDD VDD VSS VSS gf180mcu_as_sc_mcu7t3v3__fill_1
XFILLER_37_244 VDD VDD VSS VSS gf180mcu_as_sc_mcu7t3v3__fillcap_16
XFILLER_32_18 VDD VDD VSS VSS gf180mcu_as_sc_mcu7t3v3__fillcap_16
XFILLER_28_2 VDD VDD VSS VSS gf180mcu_as_sc_mcu7t3v3__fillcap_16
XFILLER_20_133 VDD VDD VSS VSS gf180mcu_as_sc_mcu7t3v3__fillcap_4
XTAP_TAPCELL_ROW_7_115 VDD VSS gf180mcu_as_sc_mcu7t3v3__tap_2
XFILLER_28_233 VDD VDD VSS VSS gf180mcu_as_sc_mcu7t3v3__fillcap_8
XTAP_TAPCELL_ROW_21_172 VDD VSS gf180mcu_as_sc_mcu7t3v3__tap_2
XTAP_TAPCELL_ROW_13_139 VDD VSS gf180mcu_as_sc_mcu7t3v3__tap_2
XFILLER_7_104 VDD VDD VSS VSS gf180mcu_as_sc_mcu7t3v3__fillcap_16
XFILLER_11_155 VDD VDD VSS VSS gf180mcu_as_sc_mcu7t3v3__fill_2
XFILLER_34_247 VDD VDD VSS VSS gf180mcu_as_sc_mcu7t3v3__fillcap_16
XFILLER_34_225 VDD VDD VSS VSS gf180mcu_as_sc_mcu7t3v3__fillcap_16
XFILLER_8_53 VDD VDD VSS VSS gf180mcu_as_sc_mcu7t3v3__fillcap_16
XFILLER_40_206 VDD VDD VSS VSS gf180mcu_as_sc_mcu7t3v3__fillcap_16
XFILLER_31_206 VDD VDD VSS VSS gf180mcu_as_sc_mcu7t3v3__fillcap_4
XFILLER_16_247 VDD VDD VSS VSS gf180mcu_as_sc_mcu7t3v3__fillcap_16
XFILLER_16_214 VDD VDD VSS VSS gf180mcu_as_sc_mcu7t3v3__fillcap_16
XFILLER_17_84 VDD VDD VSS VSS gf180mcu_as_sc_mcu7t3v3__fillcap_8
XFILLER_4_107 VDD VDD VSS VSS gf180mcu_as_sc_mcu7t3v3__fillcap_16
XFILLER_33_72 VDD VDD VSS VSS gf180mcu_as_sc_mcu7t3v3__fillcap_16
XFILLER_33_50 VDD VDD VSS VSS gf180mcu_as_sc_mcu7t3v3__fillcap_16
XFILLER_31_228 VDD VDD VSS VSS gf180mcu_as_sc_mcu7t3v3__fillcap_16
XFILLER_24_291 VDD VDD VSS VSS gf180mcu_as_sc_mcu7t3v3__fill_1
XFILLER_28_94 VDD VDD VSS VSS gf180mcu_as_sc_mcu7t3v3__fillcap_4
XFILLER_0_154 VDD VDD VSS VSS gf180mcu_as_sc_mcu7t3v3__fillcap_16
XFILLER_8_287 VDD VDD VSS VSS gf180mcu_as_sc_mcu7t3v3__fillcap_4
XFILLER_40_18 VDD VDD VSS VSS gf180mcu_as_sc_mcu7t3v3__fillcap_16
XFILLER_39_158 VDD VDD VSS VSS gf180mcu_as_sc_mcu7t3v3__fillcap_16
XFILLER_39_136 VDD VDD VSS VSS gf180mcu_as_sc_mcu7t3v3__fillcap_4
XFILLER_10_2 VDD VDD VSS VSS gf180mcu_as_sc_mcu7t3v3__fillcap_16
XFILLER_10_209 VDD VDD VSS VSS gf180mcu_as_sc_mcu7t3v3__fillcap_16
XFILLER_36_139 VDD VDD VSS VSS gf180mcu_as_sc_mcu7t3v3__fillcap_16
X_202__13 VDD VDD VSS VSS _202_/SN gf180mcu_as_sc_mcu7t3v3__tieh_4
XFILLER_35_18 VDD VDD VSS VSS gf180mcu_as_sc_mcu7t3v3__fillcap_16
XFILLER_27_139 VDD VDD VSS VSS gf180mcu_as_sc_mcu7t3v3__fill_1
X_195_ VDD VDD VSS VSS _225_/CLK _195_/Q _215_/RN _195_/SN _195_/D gf180mcu_as_sc_mcu7t3v3__dfsrtp_2
XFILLER_17_150 VDD VDD VSS VSS gf180mcu_as_sc_mcu7t3v3__fill_2
XFILLER_1_282 VDD VDD VSS VSS gf180mcu_as_sc_mcu7t3v3__fillcap_8
XFILLER_1_260 VDD VDD VSS VSS gf180mcu_as_sc_mcu7t3v3__fillcap_16
XFILLER_23_142 VDD VDD VSS VSS gf180mcu_as_sc_mcu7t3v3__fill_1
XPHY_EDGE_ROW_26_Left_67 VDD VSS gf180mcu_as_sc_mcu7t3v3__tap_2
XFILLER_14_197 VDD VDD VSS VSS gf180mcu_as_sc_mcu7t3v3__fill_1
XFILLER_37_212 VDD VDD VSS VSS gf180mcu_as_sc_mcu7t3v3__fillcap_16
XFILLER_20_189 VDD VDD VSS VSS gf180mcu_as_sc_mcu7t3v3__fill_1
X_178_ VDD VDD VSS VSS _183_/B _207_/Q _207_/D gf180mcu_as_sc_mcu7t3v3__and2_2
XTAP_TAPCELL_ROW_38_240 VDD VSS gf180mcu_as_sc_mcu7t3v3__tap_2
XFILLER_22_41 VDD VDD VSS VSS gf180mcu_as_sc_mcu7t3v3__fill_1
XTAP_TAPCELL_ROW_21_173 VDD VSS gf180mcu_as_sc_mcu7t3v3__tap_2
XTAP_TAPCELL_ROW_7_116 VDD VSS gf180mcu_as_sc_mcu7t3v3__tap_2
XFILLER_40_2 VDD VDD VSS VSS gf180mcu_as_sc_mcu7t3v3__fillcap_16
XFILLER_6_171 VDD VDD VSS VSS gf180mcu_as_sc_mcu7t3v3__fillcap_4
XFILLER_6_193 VDD VDD VSS VSS gf180mcu_as_sc_mcu7t3v3__fillcap_16
XFILLER_17_96 VDD VDD VSS VSS gf180mcu_as_sc_mcu7t3v3__fill_2
XFILLER_3_174 VDD VDD VSS VSS gf180mcu_as_sc_mcu7t3v3__fillcap_16
XFILLER_38_18 VDD VDD VSS VSS gf180mcu_as_sc_mcu7t3v3__fillcap_16
XPHY_EDGE_ROW_29_Left_70 VDD VSS gf180mcu_as_sc_mcu7t3v3__tap_2
XFILLER_22_229 VDD VDD VSS VSS gf180mcu_as_sc_mcu7t3v3__fillcap_16
XFILLER_13_218 VDD VDD VSS VSS gf180mcu_as_sc_mcu7t3v3__fillcap_16
XPHY_EDGE_ROW_13_Left_54 VDD VSS gf180mcu_as_sc_mcu7t3v3__tap_2
XFILLER_21_273 VDD VDD VSS VSS gf180mcu_as_sc_mcu7t3v3__fillcap_4
XFILLER_0_188 VDD VDD VSS VSS gf180mcu_as_sc_mcu7t3v3__fillcap_16
XFILLER_39_104 VDD VDD VSS VSS gf180mcu_as_sc_mcu7t3v3__fillcap_16
XFILLER_5_66 VDD VDD VSS VSS gf180mcu_as_sc_mcu7t3v3__fillcap_4
XFILLER_5_88 VDD VDD VSS VSS gf180mcu_as_sc_mcu7t3v3__fillcap_16
XFILLER_39_72 VDD VDD VSS VSS gf180mcu_as_sc_mcu7t3v3__fillcap_16
XFILLER_39_50 VDD VDD VSS VSS gf180mcu_as_sc_mcu7t3v3__fillcap_16
XFILLER_36_107 VDD VDD VSS VSS gf180mcu_as_sc_mcu7t3v3__fillcap_16
XFILLER_30_85 VDD VDD VSS VSS gf180mcu_as_sc_mcu7t3v3__fillcap_16
XFILLER_4_291 VDD VDD VSS VSS gf180mcu_as_sc_mcu7t3v3__fill_1
XFILLER_26_195 VDD VDD VSS VSS gf180mcu_as_sc_mcu7t3v3__fill_2
XFILLER_26_173 VDD VDD VSS VSS gf180mcu_as_sc_mcu7t3v3__fill_2
XFILLER_25_30 VDD VDD VSS VSS gf180mcu_as_sc_mcu7t3v3__fill_2
X_194_ VDD VDD VSS VSS _226_/CLK _194_/Q _215_/RN _194_/SN _194_/D gf180mcu_as_sc_mcu7t3v3__dfsrtp_2
XFILLER_18_107 VDD VDD VSS VSS gf180mcu_as_sc_mcu7t3v3__fill_2
XFILLER_2_34 VDD VDD VSS VSS gf180mcu_as_sc_mcu7t3v3__fill_1
XPHY_EDGE_ROW_1_Left_42 VDD VSS gf180mcu_as_sc_mcu7t3v3__tap_2
XFILLER_11_54 VDD VDD VSS VSS gf180mcu_as_sc_mcu7t3v3__fill_2
XTAP_TAPCELL_ROW_24_182 VDD VSS gf180mcu_as_sc_mcu7t3v3__tap_2
X_177_ VDD VDD VSS VSS _183_/B _206_/Q _206_/D gf180mcu_as_sc_mcu7t3v3__and2_2
XTAP_TAPCELL_ROW_38_241 VDD VSS gf180mcu_as_sc_mcu7t3v3__tap_2
XFILLER_28_279 VDD VDD VSS VSS gf180mcu_as_sc_mcu7t3v3__fillcap_8
XFILLER_22_20 VDD VDD VSS VSS gf180mcu_as_sc_mcu7t3v3__fill_1
XTAP_TAPCELL_ROW_7_117 VDD VSS gf180mcu_as_sc_mcu7t3v3__tap_2
XFILLER_27_290 VDD VDD VSS VSS gf180mcu_as_sc_mcu7t3v3__fill_2
XFILLER_0_2 VDD VDD VSS VSS gf180mcu_as_sc_mcu7t3v3__fillcap_16
XFILLER_33_282 VDD VDD VSS VSS gf180mcu_as_sc_mcu7t3v3__fillcap_8
XFILLER_33_260 VDD VDD VSS VSS gf180mcu_as_sc_mcu7t3v3__fillcap_16
XFILLER_33_2 VDD VDD VSS VSS gf180mcu_as_sc_mcu7t3v3__fillcap_16
XFILLER_25_249 VDD VDD VSS VSS gf180mcu_as_sc_mcu7t3v3__fillcap_16
X_217__53 VDD VDD VSS VSS _217_/SN gf180mcu_as_sc_mcu7t3v3__tieh_4
XFILLER_16_238 VDD VDD VSS VSS gf180mcu_as_sc_mcu7t3v3__fillcap_4
XFILLER_3_120 VDD VDD VSS VSS gf180mcu_as_sc_mcu7t3v3__fillcap_16
XFILLER_3_142 VDD VDD VSS VSS gf180mcu_as_sc_mcu7t3v3__fillcap_16
XTAP_TAPCELL_ROW_32_214 VDD VSS gf180mcu_as_sc_mcu7t3v3__tap_2
XFILLER_30_263 VDD VDD VSS VSS gf180mcu_as_sc_mcu7t3v3__fillcap_16
XFILLER_30_241 VDD VDD VSS VSS gf180mcu_as_sc_mcu7t3v3__fillcap_4
XFILLER_15_282 VDD VDD VSS VSS gf180mcu_as_sc_mcu7t3v3__fillcap_8
XPHY_EDGE_ROW_26_Right_26 VDD VSS gf180mcu_as_sc_mcu7t3v3__tap_2
XPHY_EDGE_ROW_17_Right_17 VDD VSS gf180mcu_as_sc_mcu7t3v3__tap_2
XPHY_EDGE_ROW_35_Right_35 VDD VSS gf180mcu_as_sc_mcu7t3v3__tap_2
XPHY_EDGE_ROW_30_Left_71 VDD VSS gf180mcu_as_sc_mcu7t3v3__tap_2
XFILLER_5_34 VDD VDD VSS VSS gf180mcu_as_sc_mcu7t3v3__fillcap_16
XFILLER_12_263 VDD VDD VSS VSS gf180mcu_as_sc_mcu7t3v3__fillcap_16
XFILLER_38_193 VDD VDD VSS VSS gf180mcu_as_sc_mcu7t3v3__fillcap_16
XFILLER_38_171 VDD VDD VSS VSS gf180mcu_as_sc_mcu7t3v3__fillcap_4
Xclkbuf_3_1__f_clk_i VDD VDD VSS VSS clkbuf_0_clk_i/Y _205_/CLK gf180mcu_as_sc_mcu7t3v3__clkbuff_12
XFILLER_30_53 VDD VDD VSS VSS gf180mcu_as_sc_mcu7t3v3__fillcap_16
XFILLER_35_174 VDD VDD VSS VSS gf180mcu_as_sc_mcu7t3v3__fillcap_16
X_193_ VDD VDD VSS VSS _225_/CLK _193_/Q _215_/RN _193_/SN _193_/D gf180mcu_as_sc_mcu7t3v3__dfsrtp_2
XFILLER_32_177 VDD VDD VSS VSS gf180mcu_as_sc_mcu7t3v3__fillcap_16
XFILLER_32_155 VDD VDD VSS VSS gf180mcu_as_sc_mcu7t3v3__fillcap_16
XFILLER_17_152 VDD VDD VSS VSS gf180mcu_as_sc_mcu7t3v3__fill_1
XFILLER_23_166 VDD VDD VSS VSS gf180mcu_as_sc_mcu7t3v3__fillcap_8
XFILLER_36_85 VDD VDD VSS VSS gf180mcu_as_sc_mcu7t3v3__fillcap_16
XTAP_TAPCELL_ROW_24_183 VDD VSS gf180mcu_as_sc_mcu7t3v3__tap_2
XFILLER_14_177 VDD VDD VSS VSS gf180mcu_as_sc_mcu7t3v3__fill_2
XFILLER_14_166 VDD VDD VSS VSS gf180mcu_as_sc_mcu7t3v3__fillcap_8
XFILLER_14_111 VDD VDD VSS VSS gf180mcu_as_sc_mcu7t3v3__fill_2
X_176_ VDD VDD VSS VSS _183_/B _205_/Q _205_/D gf180mcu_as_sc_mcu7t3v3__and2_2
XFILLER_36_291 VDD VDD VSS VSS gf180mcu_as_sc_mcu7t3v3__fill_1
XFILLER_28_247 VDD VDD VSS VSS gf180mcu_as_sc_mcu7t3v3__fillcap_16
XFILLER_28_225 VDD VDD VSS VSS gf180mcu_as_sc_mcu7t3v3__fillcap_4
XFILLER_19_203 VDD VDD VSS VSS gf180mcu_as_sc_mcu7t3v3__fillcap_4
XFILLER_8_34 VDD VDD VSS VSS gf180mcu_as_sc_mcu7t3v3__fill_1
XFILLER_11_147 VDD VDD VSS VSS gf180mcu_as_sc_mcu7t3v3__fillcap_8
X_159_ VDD VDD VSS VSS _194_/Q _159_/B _159_/C _195_/Q _195_/D gf180mcu_as_sc_mcu7t3v3__ao22_2
XFILLER_26_2 VDD VDD VSS VSS gf180mcu_as_sc_mcu7t3v3__fillcap_16
XFILLER_18_291 VDD VDD VSS VSS gf180mcu_as_sc_mcu7t3v3__fill_1
X_226__43 VDD VDD VSS VSS _226_/SN gf180mcu_as_sc_mcu7t3v3__tieh_4
XTAP_TAPCELL_ROW_32_215 VDD VSS gf180mcu_as_sc_mcu7t3v3__tap_2
X_223__46 VDD VDD VSS VSS _223_/SN gf180mcu_as_sc_mcu7t3v3__tieh_4
XFILLER_8_279 VDD VDD VSS VSS gf180mcu_as_sc_mcu7t3v3__fillcap_8
XFILLER_12_220 VDD VDD VSS VSS gf180mcu_as_sc_mcu7t3v3__fillcap_16
XFILLER_7_290 VDD VDD VSS VSS gf180mcu_as_sc_mcu7t3v3__fill_2
XFILLER_35_142 VDD VDD VSS VSS gf180mcu_as_sc_mcu7t3v3__fillcap_16
XFILLER_35_120 VDD VDD VSS VSS gf180mcu_as_sc_mcu7t3v3__fillcap_16
X_192_ VDD VDD VSS VSS _221_/CLK _192_/Q _221_/SN _192_/SN _192_/D gf180mcu_as_sc_mcu7t3v3__dfsrtp_2
XFILLER_26_197 VDD VDD VSS VSS gf180mcu_as_sc_mcu7t3v3__fill_1
XFILLER_25_76 VDD VDD VSS VSS gf180mcu_as_sc_mcu7t3v3__fill_1
XFILLER_25_32 VDD VDD VSS VSS gf180mcu_as_sc_mcu7t3v3__fill_1
XFILLER_18_109 VDD VDD VSS VSS gf180mcu_as_sc_mcu7t3v3__fill_1
XFILLER_32_123 VDD VDD VSS VSS gf180mcu_as_sc_mcu7t3v3__fillcap_16
XFILLER_32_101 VDD VDD VSS VSS gf180mcu_as_sc_mcu7t3v3__fillcap_4
XFILLER_17_142 VDD VDD VSS VSS gf180mcu_as_sc_mcu7t3v3__fillcap_8
XFILLER_17_131 VDD VDD VSS VSS gf180mcu_as_sc_mcu7t3v3__fillcap_8
XFILLER_2_69 VDD VDD VSS VSS gf180mcu_as_sc_mcu7t3v3__fillcap_16
XFILLER_11_34 VDD VDD VSS VSS gf180mcu_as_sc_mcu7t3v3__fillcap_16
XFILLER_36_53 VDD VDD VSS VSS gf180mcu_as_sc_mcu7t3v3__fillcap_16
XTAP_TAPCELL_ROW_24_184 VDD VSS gf180mcu_as_sc_mcu7t3v3__tap_2
X_175_ VDD VDD VSS VSS _183_/B _221_/Q _175_/B _214_/Q gf180mcu_as_sc_mcu7t3v3__aoi21_2
XFILLER_20_137 VDD VDD VSS VSS gf180mcu_as_sc_mcu7t3v3__fill_1
XFILLER_20_104 VDD VDD VSS VSS gf180mcu_as_sc_mcu7t3v3__fill_1
XFILLER_22_33 VDD VDD VSS VSS gf180mcu_as_sc_mcu7t3v3__fill_2
XFILLER_19_248 VDD VDD VSS VSS gf180mcu_as_sc_mcu7t3v3__fillcap_16
XFILLER_11_115 VDD VDD VSS VSS gf180mcu_as_sc_mcu7t3v3__fillcap_4
X_158_ VDD VDD VSS VSS _193_/Q _159_/B _159_/C _194_/Q _194_/D gf180mcu_as_sc_mcu7t3v3__ao22_2
XFILLER_19_2 VDD VDD VSS VSS gf180mcu_as_sc_mcu7t3v3__fillcap_16
XFILLER_17_55 VDD VDD VSS VSS gf180mcu_as_sc_mcu7t3v3__fill_2
XTAP_TAPCELL_ROW_3_100 VDD VSS gf180mcu_as_sc_mcu7t3v3__tap_2
XTAP_TAPCELL_ROW_32_216 VDD VSS gf180mcu_as_sc_mcu7t3v3__tap_2
XFILLER_30_287 VDD VDD VSS VSS gf180mcu_as_sc_mcu7t3v3__fillcap_4
XFILLER_21_265 VDD VDD VSS VSS gf180mcu_as_sc_mcu7t3v3__fillcap_8
XPHY_EDGE_ROW_3_Right_3 VDD VSS gf180mcu_as_sc_mcu7t3v3__tap_2
XFILLER_28_98 VDD VDD VSS VSS gf180mcu_as_sc_mcu7t3v3__fill_2
XFILLER_12_287 VDD VDD VSS VSS gf180mcu_as_sc_mcu7t3v3__fillcap_4
XFILLER_8_225 VDD VDD VSS VSS gf180mcu_as_sc_mcu7t3v3__fillcap_16
XFILLER_8_247 VDD VDD VSS VSS gf180mcu_as_sc_mcu7t3v3__fillcap_16
XPHY_EDGE_ROW_17_Left_58 VDD VSS gf180mcu_as_sc_mcu7t3v3__tap_2
XFILLER_14_34 VDD VDD VSS VSS gf180mcu_as_sc_mcu7t3v3__fill_1
XFILLER_5_206 VDD VDD VSS VSS gf180mcu_as_sc_mcu7t3v3__fillcap_4
XFILLER_5_228 VDD VDD VSS VSS gf180mcu_as_sc_mcu7t3v3__fillcap_16
XFILLER_26_187 VDD VDD VSS VSS gf180mcu_as_sc_mcu7t3v3__fillcap_8
XFILLER_2_209 VDD VDD VSS VSS gf180mcu_as_sc_mcu7t3v3__fillcap_16
X_191_ VDD VDD VSS VSS _221_/CLK _191_/Q _221_/SN _191_/SN _191_/D gf180mcu_as_sc_mcu7t3v3__dfsrtp_2
XFILLER_17_110 VDD VDD VSS VSS gf180mcu_as_sc_mcu7t3v3__fillcap_4
XFILLER_2_37 VDD VDD VSS VSS gf180mcu_as_sc_mcu7t3v3__fillcap_16
XFILLER_31_190 VDD VDD VSS VSS gf180mcu_as_sc_mcu7t3v3__fillcap_16
XFILLER_23_113 VDD VDD VSS VSS gf180mcu_as_sc_mcu7t3v3__fillcap_16
XTAP_TAPCELL_ROW_18_160 VDD VSS gf180mcu_as_sc_mcu7t3v3__tap_2
XFILLER_39_290 VDD VDD VSS VSS gf180mcu_as_sc_mcu7t3v3__fill_2
XTAP_TAPCELL_ROW_24_185 VDD VSS gf180mcu_as_sc_mcu7t3v3__tap_2
X_174_ VDD VDD VSS VSS _175_/B _225_/Q _174_/B _226_/Q gf180mcu_as_sc_mcu7t3v3__ao21_2
XFILLER_14_113 VDD VDD VSS VSS gf180mcu_as_sc_mcu7t3v3__fill_1
XFILLER_9_183 VDD VDD VSS VSS gf180mcu_as_sc_mcu7t3v3__fillcap_16
XFILLER_19_216 VDD VDD VSS VSS gf180mcu_as_sc_mcu7t3v3__fillcap_16
XPHY_EDGE_ROW_5_Left_46 VDD VSS gf180mcu_as_sc_mcu7t3v3__tap_2
XFILLER_27_282 VDD VDD VSS VSS gf180mcu_as_sc_mcu7t3v3__fillcap_8
X_157_ VDD VDD VSS VSS _192_/Q _159_/B _159_/C _193_/Q _193_/D gf180mcu_as_sc_mcu7t3v3__ao22_2
X_226_ VDD VDD VSS VSS _226_/CLK _226_/Q _226_/RN _226_/SN _226_/D gf180mcu_as_sc_mcu7t3v3__dfsrtp_2
XFILLER_8_69 VDD VDD VSS VSS gf180mcu_as_sc_mcu7t3v3__fillcap_16
XFILLER_10_193 VDD VDD VSS VSS gf180mcu_as_sc_mcu7t3v3__fillcap_16
XFILLER_24_263 VDD VDD VSS VSS gf180mcu_as_sc_mcu7t3v3__fillcap_16
XFILLER_24_230 VDD VDD VSS VSS gf180mcu_as_sc_mcu7t3v3__fill_1
XTAP_TAPCELL_ROW_3_101 VDD VSS gf180mcu_as_sc_mcu7t3v3__tap_2
XFILLER_33_88 VDD VDD VSS VSS gf180mcu_as_sc_mcu7t3v3__fillcap_16
XFILLER_33_66 VDD VDD VSS VSS gf180mcu_as_sc_mcu7t3v3__fillcap_4
XTAP_TAPCELL_ROW_32_217 VDD VSS gf180mcu_as_sc_mcu7t3v3__tap_2
XTAP_TAPCELL_ROW_40_250 VDD VSS gf180mcu_as_sc_mcu7t3v3__tap_2
XFILLER_31_2 VDD VDD VSS VSS gf180mcu_as_sc_mcu7t3v3__fillcap_16
XFILLER_21_277 VDD VDD VSS VSS gf180mcu_as_sc_mcu7t3v3__fill_2
X_209_ VDD VDD VSS VSS _219_/CLK _209_/Q _217_/RN _209_/SN _209_/D gf180mcu_as_sc_mcu7t3v3__dfsrtp_2
XFILLER_0_70 VDD VDD VSS VSS gf180mcu_as_sc_mcu7t3v3__fillcap_16
XFILLER_0_104 VDD VDD VSS VSS gf180mcu_as_sc_mcu7t3v3__fillcap_16
XFILLER_12_244 VDD VDD VSS VSS gf180mcu_as_sc_mcu7t3v3__fill_1
XPHY_EDGE_ROW_22_Right_22 VDD VSS gf180mcu_as_sc_mcu7t3v3__tap_2
XPHY_EDGE_ROW_13_Right_13 VDD VSS gf180mcu_as_sc_mcu7t3v3__tap_2
XPHY_EDGE_ROW_40_Right_40 VDD VSS gf180mcu_as_sc_mcu7t3v3__tap_2
XPHY_EDGE_ROW_31_Right_31 VDD VSS gf180mcu_as_sc_mcu7t3v3__tap_2
XFILLER_30_34 VDD VDD VSS VSS gf180mcu_as_sc_mcu7t3v3__fill_1
XPHY_EDGE_ROW_34_Left_75 VDD VSS gf180mcu_as_sc_mcu7t3v3__tap_2
XFILLER_29_174 VDD VDD VSS VSS gf180mcu_as_sc_mcu7t3v3__fillcap_16
XFILLER_26_111 VDD VDD VSS VSS gf180mcu_as_sc_mcu7t3v3__fill_2
XTAP_TAPCELL_ROW_27_194 VDD VSS gf180mcu_as_sc_mcu7t3v3__tap_2
XFILLER_26_177 VDD VDD VSS VSS gf180mcu_as_sc_mcu7t3v3__fill_2
X_190_ VDD VDD VSS VSS _221_/CLK _190_/Q _221_/SN _190_/SN _190_/D gf180mcu_as_sc_mcu7t3v3__dfsrtp_2
X_187__28 VDD VDD VSS VSS _187_/SN gf180mcu_as_sc_mcu7t3v3__tieh_4
XFILLER_1_276 VDD VDD VSS VSS gf180mcu_as_sc_mcu7t3v3__fillcap_4
XFILLER_9_2 VDD VDD VSS VSS gf180mcu_as_sc_mcu7t3v3__fillcap_16
XTAP_TAPCELL_ROW_18_161 VDD VSS gf180mcu_as_sc_mcu7t3v3__tap_2
X_173_ VDD VDD VSS VSS _204_/Q _173_/B _173_/C _203_/Q _204_/D gf180mcu_as_sc_mcu7t3v3__ao22_2
XFILLER_37_228 VDD VDD VSS VSS gf180mcu_as_sc_mcu7t3v3__fillcap_16
XFILLER_37_206 VDD VDD VSS VSS gf180mcu_as_sc_mcu7t3v3__fillcap_4
XPHY_EDGE_ROW_21_Left_62 VDD VSS gf180mcu_as_sc_mcu7t3v3__tap_2
XTAP_TAPCELL_ROW_6_110 VDD VSS gf180mcu_as_sc_mcu7t3v3__tap_2
XFILLER_11_139 VDD VDD VSS VSS gf180mcu_as_sc_mcu7t3v3__fill_1
XFILLER_34_209 VDD VDD VSS VSS gf180mcu_as_sc_mcu7t3v3__fillcap_16
X_225_ VDD VDD VSS VSS _225_/CLK _225_/Q _226_/RN _225_/SN _225_/D gf180mcu_as_sc_mcu7t3v3__dfsrtp_2
X_156_ VDD VDD VSS VSS _191_/Q _159_/B _159_/C _192_/Q _192_/D gf180mcu_as_sc_mcu7t3v3__ao22_2
XFILLER_8_37 VDD VDD VSS VSS gf180mcu_as_sc_mcu7t3v3__fillcap_16
XTAP_TAPCELL_ROW_12_134 VDD VSS gf180mcu_as_sc_mcu7t3v3__tap_2
XTAP_TAPCELL_ROW_35_226 VDD VSS gf180mcu_as_sc_mcu7t3v3__tap_2
Xclkbuf_3_4__f_clk_i VDD VDD VSS VSS clkbuf_0_clk_i/Y _213_/CLK gf180mcu_as_sc_mcu7t3v3__clkbuff_12
XFILLER_33_34 VDD VDD VSS VSS gf180mcu_as_sc_mcu7t3v3__fillcap_16
XFILLER_17_68 VDD VDD VSS VSS gf180mcu_as_sc_mcu7t3v3__fill_2
XTAP_TAPCELL_ROW_40_251 VDD VSS gf180mcu_as_sc_mcu7t3v3__tap_2
XFILLER_24_2 VDD VDD VSS VSS gf180mcu_as_sc_mcu7t3v3__fillcap_16
X_139_ VDD VDD VSS VSS _186_/D _139_/B _166_/S gf180mcu_as_sc_mcu7t3v3__nor2_2
XFILLER_15_264 VDD VDD VSS VSS gf180mcu_as_sc_mcu7t3v3__fillcap_16
X_208_ VDD VDD VSS VSS _212_/CLK _208_/Q _208_/RN _208_/SN _208_/D gf180mcu_as_sc_mcu7t3v3__dfsrtp_2
XFILLER_28_78 VDD VDD VSS VSS gf180mcu_as_sc_mcu7t3v3__fillcap_4
XFILLER_28_34 VDD VDD VSS VSS gf180mcu_as_sc_mcu7t3v3__fill_1
XFILLER_0_138 VDD VDD VSS VSS gf180mcu_as_sc_mcu7t3v3__fillcap_16
XFILLER_7_260 VDD VDD VSS VSS gf180mcu_as_sc_mcu7t3v3__fillcap_16
XFILLER_7_282 VDD VDD VSS VSS gf180mcu_as_sc_mcu7t3v3__fillcap_8
XFILLER_39_88 VDD VDD VSS VSS gf180mcu_as_sc_mcu7t3v3__fillcap_16
XFILLER_39_66 VDD VDD VSS VSS gf180mcu_as_sc_mcu7t3v3__fillcap_4
XFILLER_29_142 VDD VDD VSS VSS gf180mcu_as_sc_mcu7t3v3__fillcap_16
XFILLER_29_120 VDD VDD VSS VSS gf180mcu_as_sc_mcu7t3v3__fillcap_16
XFILLER_4_241 VDD VDD VSS VSS gf180mcu_as_sc_mcu7t3v3__fillcap_4
XFILLER_4_263 VDD VDD VSS VSS gf180mcu_as_sc_mcu7t3v3__fillcap_16
XFILLER_1_244 VDD VDD VSS VSS gf180mcu_as_sc_mcu7t3v3__fillcap_16
XTAP_TAPCELL_ROW_27_195 VDD VSS gf180mcu_as_sc_mcu7t3v3__tap_2
XFILLER_36_34 VDD VDD VSS VSS gf180mcu_as_sc_mcu7t3v3__fill_1
XFILLER_23_137 VDD VDD VSS VSS gf180mcu_as_sc_mcu7t3v3__fill_2
X_172_ VDD VDD VSS VSS _203_/Q _172_/B _173_/C _203_/D gf180mcu_as_sc_mcu7t3v3__mux2_2
XFILLER_22_170 VDD VDD VSS VSS gf180mcu_as_sc_mcu7t3v3__fillcap_4
XFILLER_20_107 VDD VDD VSS VSS gf180mcu_as_sc_mcu7t3v3__fill_1
XFILLER_22_25 VDD VDD VSS VSS gf180mcu_as_sc_mcu7t3v3__fillcap_8
XTAP_TAPCELL_ROW_29_202 VDD VSS gf180mcu_as_sc_mcu7t3v3__tap_2
X_155_ VDD VDD VSS VSS _190_/Q _159_/B _159_/C _191_/Q _191_/D gf180mcu_as_sc_mcu7t3v3__ao22_2
X_224_ VDD VDD VSS VSS _224_/CLK _224_/Q _224_/RN _224_/SN _224_/D gf180mcu_as_sc_mcu7t3v3__dfsrtp_2
XFILLER_19_207 VDD VDD VSS VSS gf180mcu_as_sc_mcu7t3v3__fill_2
XTAP_TAPCELL_ROW_6_111 VDD VSS gf180mcu_as_sc_mcu7t3v3__tap_2
XFILLER_6_155 VDD VDD VSS VSS gf180mcu_as_sc_mcu7t3v3__fillcap_16
XFILLER_6_177 VDD VDD VSS VSS gf180mcu_as_sc_mcu7t3v3__fillcap_16
XTAP_TAPCELL_ROW_12_135 VDD VSS gf180mcu_as_sc_mcu7t3v3__tap_2
XTAP_TAPCELL_ROW_35_227 VDD VSS gf180mcu_as_sc_mcu7t3v3__tap_2
XFILLER_33_276 VDD VDD VSS VSS gf180mcu_as_sc_mcu7t3v3__fillcap_4
XFILLER_24_287 VDD VDD VSS VSS gf180mcu_as_sc_mcu7t3v3__fillcap_4
XFILLER_3_136 VDD VDD VSS VSS gf180mcu_as_sc_mcu7t3v3__fillcap_4
XFILLER_3_158 VDD VDD VSS VSS gf180mcu_as_sc_mcu7t3v3__fillcap_16
XTAP_TAPCELL_ROW_40_252 VDD VSS gf180mcu_as_sc_mcu7t3v3__tap_2
XFILLER_30_279 VDD VDD VSS VSS gf180mcu_as_sc_mcu7t3v3__fillcap_8
X_138_ VDD VDD VSS VSS _139_/B _186_/Q _138_/B _147_/D gf180mcu_as_sc_mcu7t3v3__aoi21_2
XFILLER_15_232 VDD VDD VSS VSS gf180mcu_as_sc_mcu7t3v3__fillcap_16
X_207_ VDD VDD VSS VSS _213_/CLK _207_/Q _212_/RN _207_/SN _207_/D gf180mcu_as_sc_mcu7t3v3__dfsrtp_2
XFILLER_21_279 VDD VDD VSS VSS gf180mcu_as_sc_mcu7t3v3__fill_1
XFILLER_12_279 VDD VDD VSS VSS gf180mcu_as_sc_mcu7t3v3__fillcap_8
XFILLER_14_37 VDD VDD VSS VSS gf180mcu_as_sc_mcu7t3v3__fillcap_8
XPHY_EDGE_ROW_7_Right_7 VDD VSS gf180mcu_as_sc_mcu7t3v3__tap_2
XFILLER_11_290 VDD VDD VSS VSS gf180mcu_as_sc_mcu7t3v3__fill_2
XFILLER_39_34 VDD VDD VSS VSS gf180mcu_as_sc_mcu7t3v3__fillcap_16
XFILLER_30_69 VDD VDD VSS VSS gf180mcu_as_sc_mcu7t3v3__fillcap_16
X_199__16 VDD VDD VSS VSS _199_/SN gf180mcu_as_sc_mcu7t3v3__tieh_4
XFILLER_20_80 VDD VDD VSS VSS gf180mcu_as_sc_mcu7t3v3__fill_2
XFILLER_26_113 VDD VDD VSS VSS gf180mcu_as_sc_mcu7t3v3__fill_1
XFILLER_1_212 VDD VDD VSS VSS gf180mcu_as_sc_mcu7t3v3__fillcap_16
X_196__19 VDD VDD VSS VSS _196_/SN gf180mcu_as_sc_mcu7t3v3__tieh_4
XTAP_TAPCELL_ROW_27_196 VDD VSS gf180mcu_as_sc_mcu7t3v3__tap_2
XFILLER_17_102 VDD VDD VSS VSS gf180mcu_as_sc_mcu7t3v3__fillcap_4
XTAP_TAPCELL_ROW_2_94 VDD VSS gf180mcu_as_sc_mcu7t3v3__tap_2
XFILLER_2_18 VDD VDD VSS VSS gf180mcu_as_sc_mcu7t3v3__fillcap_16
XFILLER_39_282 VDD VDD VSS VSS gf180mcu_as_sc_mcu7t3v3__fillcap_8
XFILLER_39_260 VDD VDD VSS VSS gf180mcu_as_sc_mcu7t3v3__fillcap_16
X_171_ VDD VDD VSS VSS _173_/C _171_/B _171_/A gf180mcu_as_sc_mcu7t3v3__nor2b_2
XFILLER_36_263 VDD VDD VSS VSS gf180mcu_as_sc_mcu7t3v3__fillcap_16
XFILLER_36_241 VDD VDD VSS VSS gf180mcu_as_sc_mcu7t3v3__fillcap_4
XFILLER_3_72 VDD VDD VSS VSS gf180mcu_as_sc_mcu7t3v3__fillcap_16
XFILLER_3_50 VDD VDD VSS VSS gf180mcu_as_sc_mcu7t3v3__fillcap_16
XFILLER_9_142 VDD VDD VSS VSS gf180mcu_as_sc_mcu7t3v3__fillcap_4
XTAP_TAPCELL_ROW_29_203 VDD VSS gf180mcu_as_sc_mcu7t3v3__tap_2
X_223_ VDD VDD VSS VSS _224_/CLK _224_/D _224_/RN _223_/SN _223_/D gf180mcu_as_sc_mcu7t3v3__dfsrtp_2
XFILLER_22_37 VDD VDD VSS VSS gf180mcu_as_sc_mcu7t3v3__fillcap_4
XFILLER_6_101 VDD VDD VSS VSS gf180mcu_as_sc_mcu7t3v3__fillcap_4
XTAP_TAPCELL_ROW_6_112 VDD VSS gf180mcu_as_sc_mcu7t3v3__tap_2
XTAP_TAPCELL_ROW_12_136 VDD VSS gf180mcu_as_sc_mcu7t3v3__tap_2
XTAP_TAPCELL_ROW_35_228 VDD VSS gf180mcu_as_sc_mcu7t3v3__tap_2
XFILLER_33_244 VDD VDD VSS VSS gf180mcu_as_sc_mcu7t3v3__fillcap_16
X_154_ VDD VDD VSS VSS _189_/Q _159_/B _159_/C _190_/Q _190_/D gf180mcu_as_sc_mcu7t3v3__ao22_2
XFILLER_18_263 VDD VDD VSS VSS gf180mcu_as_sc_mcu7t3v3__fillcap_16
XFILLER_6_123 VDD VDD VSS VSS gf180mcu_as_sc_mcu7t3v3__fillcap_16
XFILLER_3_104 VDD VDD VSS VSS gf180mcu_as_sc_mcu7t3v3__fillcap_16
XTAP_TAPCELL_ROW_40_253 VDD VSS gf180mcu_as_sc_mcu7t3v3__tap_2
XFILLER_30_247 VDD VDD VSS VSS gf180mcu_as_sc_mcu7t3v3__fillcap_16
XFILLER_30_225 VDD VDD VSS VSS gf180mcu_as_sc_mcu7t3v3__fillcap_16
X_137_ VDD VDD VSS VSS _213_/D _186_/Q _147_/D _138_/B _166_/S gf180mcu_as_sc_mcu7t3v3__ao31_2
X_208__37 VDD VDD VSS VSS _208_/SN gf180mcu_as_sc_mcu7t3v3__tieh_4
X_206_ VDD VDD VSS VSS _219_/CLK _206_/Q _211_/RN _206_/SN _206_/D gf180mcu_as_sc_mcu7t3v3__dfsrtp_2
XFILLER_20_291 VDD VDD VSS VSS gf180mcu_as_sc_mcu7t3v3__fill_1
XFILLER_5_18 VDD VDD VSS VSS gf180mcu_as_sc_mcu7t3v3__fillcap_16
XFILLER_12_236 VDD VDD VSS VSS gf180mcu_as_sc_mcu7t3v3__fillcap_8
XFILLER_12_247 VDD VDD VSS VSS gf180mcu_as_sc_mcu7t3v3__fillcap_16
XFILLER_38_177 VDD VDD VSS VSS gf180mcu_as_sc_mcu7t3v3__fillcap_16
XFILLER_38_155 VDD VDD VSS VSS gf180mcu_as_sc_mcu7t3v3__fillcap_16
XFILLER_30_37 VDD VDD VSS VSS gf180mcu_as_sc_mcu7t3v3__fillcap_16
Xfanout1 VDD VDD VSS VSS _221_/Q _213_/D gf180mcu_as_sc_mcu7t3v3__buff_2
XFILLER_35_158 VDD VDD VSS VSS gf180mcu_as_sc_mcu7t3v3__fillcap_16
XFILLER_35_136 VDD VDD VSS VSS gf180mcu_as_sc_mcu7t3v3__fillcap_4
XFILLER_4_287 VDD VDD VSS VSS gf180mcu_as_sc_mcu7t3v3__fillcap_4
XPHY_EDGE_ROW_38_Left_79 VDD VSS gf180mcu_as_sc_mcu7t3v3__tap_2
XFILLER_25_26 VDD VDD VSS VSS gf180mcu_as_sc_mcu7t3v3__fillcap_4
XFILLER_40_172 VDD VDD VSS VSS gf180mcu_as_sc_mcu7t3v3__fillcap_16
XFILLER_32_139 VDD VDD VSS VSS gf180mcu_as_sc_mcu7t3v3__fillcap_16
XTAP_TAPCELL_ROW_27_197 VDD VSS gf180mcu_as_sc_mcu7t3v3__tap_2
X_195__20 VDD VDD VSS VSS _195_/SN gf180mcu_as_sc_mcu7t3v3__tieh_4
XTAP_TAPCELL_ROW_2_95 VDD VSS gf180mcu_as_sc_mcu7t3v3__tap_2
XFILLER_23_139 VDD VDD VSS VSS gf180mcu_as_sc_mcu7t3v3__fill_1
XFILLER_0_290 VDD VDD VSS VSS gf180mcu_as_sc_mcu7t3v3__fill_2
XFILLER_36_69 VDD VDD VSS VSS gf180mcu_as_sc_mcu7t3v3__fillcap_16
X_192__23 VDD VDD VSS VSS _192_/SN gf180mcu_as_sc_mcu7t3v3__tieh_4
X_170_ VDD VDD VSS VSS _172_/B _171_/A _171_/B _170_/C gf180mcu_as_sc_mcu7t3v3__ao21_2
XFILLER_22_161 VDD VDD VSS VSS gf180mcu_as_sc_mcu7t3v3__fill_1
XFILLER_14_128 VDD VDD VSS VSS gf180mcu_as_sc_mcu7t3v3__fill_1
XFILLER_7_2 VDD VDD VSS VSS gf180mcu_as_sc_mcu7t3v3__fillcap_16
XFILLER_28_209 VDD VDD VSS VSS gf180mcu_as_sc_mcu7t3v3__fillcap_16
XFILLER_13_150 VDD VDD VSS VSS gf180mcu_as_sc_mcu7t3v3__fill_2
XPHY_EDGE_ROW_29_Right_29 VDD VSS gf180mcu_as_sc_mcu7t3v3__tap_2
XTAP_TAPCELL_ROW_29_204 VDD VSS gf180mcu_as_sc_mcu7t3v3__tap_2
XFILLER_27_264 VDD VDD VSS VSS gf180mcu_as_sc_mcu7t3v3__fillcap_16
XFILLER_27_220 VDD VDD VSS VSS gf180mcu_as_sc_mcu7t3v3__fillcap_4
XFILLER_19_209 VDD VDD VSS VSS gf180mcu_as_sc_mcu7t3v3__fill_1
XTAP_TAPCELL_ROW_6_113 VDD VSS gf180mcu_as_sc_mcu7t3v3__tap_2
XPHY_EDGE_ROW_38_Right_38 VDD VSS gf180mcu_as_sc_mcu7t3v3__tap_2
XTAP_TAPCELL_ROW_35_229 VDD VSS gf180mcu_as_sc_mcu7t3v3__tap_2
XFILLER_33_212 VDD VDD VSS VSS gf180mcu_as_sc_mcu7t3v3__fillcap_16
X_222_ VDD VDD VSS VSS _224_/CLK _223_/D _224_/RN _222_/SN cio_sd_i gf180mcu_as_sc_mcu7t3v3__dfsrtp_2
XPHY_EDGE_ROW_25_Left_66 VDD VSS gf180mcu_as_sc_mcu7t3v3__tap_2
X_153_ VDD VDD VSS VSS _224_/Q _159_/B _159_/C _189_/Q _189_/D gf180mcu_as_sc_mcu7t3v3__ao22_2
XFILLER_18_242 VDD VDD VSS VSS gf180mcu_as_sc_mcu7t3v3__fill_2
XFILLER_8_18 VDD VDD VSS VSS gf180mcu_as_sc_mcu7t3v3__fillcap_16
XTAP_TAPCELL_ROW_12_137 VDD VSS gf180mcu_as_sc_mcu7t3v3__tap_2
XFILLER_5_190 VDD VDD VSS VSS gf180mcu_as_sc_mcu7t3v3__fillcap_16
X_136_ VDD VDD VSS VSS _185_/Q _149_/B _148_/A _145_/B _185_/D gf180mcu_as_sc_mcu7t3v3__ao22_2
X_205_ VDD VDD VSS VSS _205_/CLK _205_/Q _211_/RN _205_/SN _205_/D gf180mcu_as_sc_mcu7t3v3__dfsrtp_2
XTAP_TAPCELL_ROW_31_210 VDD VSS gf180mcu_as_sc_mcu7t3v3__tap_2
XFILLER_2_193 VDD VDD VSS VSS gf180mcu_as_sc_mcu7t3v3__fillcap_16
XFILLER_2_171 VDD VDD VSS VSS gf180mcu_as_sc_mcu7t3v3__fillcap_4
XFILLER_0_52 VDD VDD VSS VSS gf180mcu_as_sc_mcu7t3v3__fillcap_16
XFILLER_9_50 VDD VDD VSS VSS gf180mcu_as_sc_mcu7t3v3__fillcap_16
XFILLER_9_72 VDD VDD VSS VSS gf180mcu_as_sc_mcu7t3v3__fill_1
XFILLER_28_37 VDD VDD VSS VSS gf180mcu_as_sc_mcu7t3v3__fillcap_4
XFILLER_38_123 VDD VDD VSS VSS gf180mcu_as_sc_mcu7t3v3__fillcap_16
XFILLER_38_101 VDD VDD VSS VSS gf180mcu_as_sc_mcu7t3v3__fillcap_4
X_204__41 VDD VDD VSS VSS _204_/SN gf180mcu_as_sc_mcu7t3v3__tieh_4
X_119_ VDD VDD VSS VSS _120_/C _188_/Q _215_/Q gf180mcu_as_sc_mcu7t3v3__nand2_2
XFILLER_22_2 VDD VDD VSS VSS gf180mcu_as_sc_mcu7t3v3__fillcap_16
Xfanout2 VDD VDD VSS VSS _226_/RN _217_/RN gf180mcu_as_sc_mcu7t3v3__buff_2
XPHY_EDGE_ROW_12_Left_53 VDD VSS gf180mcu_as_sc_mcu7t3v3__tap_2
XFILLER_35_104 VDD VDD VSS VSS gf180mcu_as_sc_mcu7t3v3__fillcap_16
XFILLER_32_107 VDD VDD VSS VSS gf180mcu_as_sc_mcu7t3v3__fillcap_16
XFILLER_23_129 VDD VDD VSS VSS gf180mcu_as_sc_mcu7t3v3__fillcap_8
XTAP_TAPCELL_ROW_2_96 VDD VSS gf180mcu_as_sc_mcu7t3v3__tap_2
XFILLER_11_18 VDD VDD VSS VSS gf180mcu_as_sc_mcu7t3v3__fillcap_16
XFILLER_36_37 VDD VDD VSS VSS gf180mcu_as_sc_mcu7t3v3__fillcap_16
Xclkbuf_3_7__f_clk_i VDD VDD VSS VSS clkbuf_0_clk_i/Y _226_/CLK gf180mcu_as_sc_mcu7t3v3__clkbuff_12
XFILLER_14_107 VDD VDD VSS VSS gf180mcu_as_sc_mcu7t3v3__fillcap_4
XTAP_TAPCELL_ROW_9_122 VDD VSS gf180mcu_as_sc_mcu7t3v3__tap_2
XTAP_TAPCELL_ROW_15_146 VDD VSS gf180mcu_as_sc_mcu7t3v3__tap_2
XFILLER_9_199 VDD VDD VSS VSS gf180mcu_as_sc_mcu7t3v3__fillcap_8
XTAP_TAPCELL_ROW_38_238 VDD VSS gf180mcu_as_sc_mcu7t3v3__tap_2
XFILLER_36_287 VDD VDD VSS VSS gf180mcu_as_sc_mcu7t3v3__fillcap_4
XTAP_TAPCELL_ROW_29_205 VDD VSS gf180mcu_as_sc_mcu7t3v3__tap_2
X_152_ VDD VDD VSS VSS _159_/C _213_/D _218_/D _218_/Q gf180mcu_as_sc_mcu7t3v3__aoi21b_2
X_221_ VDD VDD VSS VSS _221_/CLK _221_/Q _221_/RN _221_/SN _221_/D gf180mcu_as_sc_mcu7t3v3__dfsrtp_2
XFILLER_18_210 VDD VDD VSS VSS gf180mcu_as_sc_mcu7t3v3__fillcap_16
XPHY_EDGE_ROW_0_Left_41 VDD VSS gf180mcu_as_sc_mcu7t3v3__tap_2
XFILLER_10_121 VDD VDD VSS VSS gf180mcu_as_sc_mcu7t3v3__fill_1
XFILLER_24_224 VDD VDD VSS VSS gf180mcu_as_sc_mcu7t3v3__fillcap_4
XFILLER_18_287 VDD VDD VSS VSS gf180mcu_as_sc_mcu7t3v3__fillcap_4
XFILLER_17_39 VDD VDD VSS VSS gf180mcu_as_sc_mcu7t3v3__fillcap_16
X_204_ VDD VDD VSS VSS _226_/CLK _204_/Q _204_/RN _204_/SN _204_/D gf180mcu_as_sc_mcu7t3v3__dfsrtp_2
XFILLER_24_279 VDD VDD VSS VSS gf180mcu_as_sc_mcu7t3v3__fillcap_8
XFILLER_23_290 VDD VDD VSS VSS gf180mcu_as_sc_mcu7t3v3__fill_2
XTAP_TAPCELL_ROW_31_211 VDD VSS gf180mcu_as_sc_mcu7t3v3__tap_2
XFILLER_21_249 VDD VDD VSS VSS gf180mcu_as_sc_mcu7t3v3__fillcap_16
XFILLER_21_205 VDD VDD VSS VSS gf180mcu_as_sc_mcu7t3v3__fillcap_4
X_135_ VDD VDD VSS VSS _185_/Q _184_/Q _145_/B gf180mcu_as_sc_mcu7t3v3__xor2_2
XFILLER_0_86 VDD VDD VSS VSS gf180mcu_as_sc_mcu7t3v3__fillcap_16
XFILLER_8_209 VDD VDD VSS VSS gf180mcu_as_sc_mcu7t3v3__fillcap_16
X_118_ VDD VDD VSS VSS _215_/D _118_/B _213_/D gf180mcu_as_sc_mcu7t3v3__nor2_2
XFILLER_11_260 VDD VDD VSS VSS gf180mcu_as_sc_mcu7t3v3__fillcap_16
XFILLER_11_282 VDD VDD VSS VSS gf180mcu_as_sc_mcu7t3v3__fillcap_8
XFILLER_14_18 VDD VDD VSS VSS gf180mcu_as_sc_mcu7t3v3__fillcap_16
XFILLER_37_190 VDD VDD VSS VSS gf180mcu_as_sc_mcu7t3v3__fillcap_16
XFILLER_6_85 VDD VDD VSS VSS gf180mcu_as_sc_mcu7t3v3__fillcap_16
XFILLER_34_193 VDD VDD VSS VSS gf180mcu_as_sc_mcu7t3v3__fillcap_16
XFILLER_34_171 VDD VDD VSS VSS gf180mcu_as_sc_mcu7t3v3__fillcap_4
XFILLER_31_174 VDD VDD VSS VSS gf180mcu_as_sc_mcu7t3v3__fillcap_16
XFILLER_15_72 VDD VDD VSS VSS gf180mcu_as_sc_mcu7t3v3__fillcap_4
XTAP_TAPCELL_ROW_2_97 VDD VSS gf180mcu_as_sc_mcu7t3v3__tap_2
XFILLER_22_174 VDD VDD VSS VSS gf180mcu_as_sc_mcu7t3v3__fill_1
XTAP_TAPCELL_ROW_23_180 VDD VSS gf180mcu_as_sc_mcu7t3v3__tap_2
XTAP_TAPCELL_ROW_15_147 VDD VSS gf180mcu_as_sc_mcu7t3v3__tap_2
XTAP_TAPCELL_ROW_9_123 VDD VSS gf180mcu_as_sc_mcu7t3v3__tap_2
XTAP_TAPCELL_ROW_38_239 VDD VSS gf180mcu_as_sc_mcu7t3v3__tap_2
XFILLER_22_18 VDD VDD VSS VSS gf180mcu_as_sc_mcu7t3v3__fill_2
XFILLER_27_200 VDD VDD VSS VSS gf180mcu_as_sc_mcu7t3v3__fill_1
X_151_ VDD VDD VSS VSS _225_/D _195_/Q _188_/Q _188_/D gf180mcu_as_sc_mcu7t3v3__mux2_2
X_220_ VDD VDD VSS VSS _224_/CLK _221_/D _220_/RN _224_/RN _220_/D gf180mcu_as_sc_mcu7t3v3__dfsrtp_2
XFILLER_10_111 VDD VDD VSS VSS gf180mcu_as_sc_mcu7t3v3__fill_2
XFILLER_10_177 VDD VDD VSS VSS gf180mcu_as_sc_mcu7t3v3__fillcap_16
XFILLER_18_244 VDD VDD VSS VSS gf180mcu_as_sc_mcu7t3v3__fill_1
XFILLER_32_291 VDD VDD VSS VSS gf180mcu_as_sc_mcu7t3v3__fill_1
XFILLER_24_247 VDD VDD VSS VSS gf180mcu_as_sc_mcu7t3v3__fillcap_16
X_203_ VDD VDD VSS VSS _226_/CLK _203_/Q _204_/RN _203_/SN _203_/D gf180mcu_as_sc_mcu7t3v3__dfsrtp_2
XFILLER_23_94 VDD VDD VSS VSS gf180mcu_as_sc_mcu7t3v3__fill_2
XFILLER_23_72 VDD VDD VSS VSS gf180mcu_as_sc_mcu7t3v3__fill_2
X_134_ VDD VDD VSS VSS _143_/C _185_/Q _184_/Q gf180mcu_as_sc_mcu7t3v3__nor2_2
XTAP_TAPCELL_ROW_31_212 VDD VSS gf180mcu_as_sc_mcu7t3v3__tap_2
XFILLER_14_291 VDD VDD VSS VSS gf180mcu_as_sc_mcu7t3v3__fill_1
XFILLER_9_85 VDD VDD VSS VSS gf180mcu_as_sc_mcu7t3v3__fillcap_4
X_117_ VDD VDD VSS VSS _118_/B _213_/Q _215_/Q _122_/A gf180mcu_as_sc_mcu7t3v3__aoi21_2
XFILLER_30_18 VDD VDD VSS VSS gf180mcu_as_sc_mcu7t3v3__fillcap_16
Xfanout4 VDD VDD VSS VSS _226_/RN _221_/SN gf180mcu_as_sc_mcu7t3v3__buff_2
XFILLER_7_276 VDD VDD VSS VSS gf180mcu_as_sc_mcu7t3v3__fillcap_4
XFILLER_29_158 VDD VDD VSS VSS gf180mcu_as_sc_mcu7t3v3__fillcap_16
XFILLER_29_136 VDD VDD VSS VSS gf180mcu_as_sc_mcu7t3v3__fillcap_4
X_210__35 VDD VDD VSS VSS _210_/SN gf180mcu_as_sc_mcu7t3v3__tieh_4
XFILLER_4_279 VDD VDD VSS VSS gf180mcu_as_sc_mcu7t3v3__fillcap_8
XFILLER_3_290 VDD VDD VSS VSS gf180mcu_as_sc_mcu7t3v3__fill_2
XFILLER_6_53 VDD VDD VSS VSS gf180mcu_as_sc_mcu7t3v3__fillcap_16
XFILLER_25_18 VDD VDD VSS VSS gf180mcu_as_sc_mcu7t3v3__fillcap_8
XFILLER_40_120 VDD VDD VSS VSS gf180mcu_as_sc_mcu7t3v3__fillcap_16
XFILLER_31_72 VDD VDD VSS VSS gf180mcu_as_sc_mcu7t3v3__fillcap_16
XFILLER_31_50 VDD VDD VSS VSS gf180mcu_as_sc_mcu7t3v3__fillcap_16
XFILLER_17_139 VDD VDD VSS VSS gf180mcu_as_sc_mcu7t3v3__fill_1
XFILLER_31_142 VDD VDD VSS VSS gf180mcu_as_sc_mcu7t3v3__fillcap_16
XFILLER_31_120 VDD VDD VSS VSS gf180mcu_as_sc_mcu7t3v3__fillcap_16
XFILLER_22_120 VDD VDD VSS VSS gf180mcu_as_sc_mcu7t3v3__fillcap_16
XFILLER_16_161 VDD VDD VSS VSS gf180mcu_as_sc_mcu7t3v3__fill_2
XTAP_TAPCELL_ROW_23_181 VDD VSS gf180mcu_as_sc_mcu7t3v3__tap_2
XFILLER_22_186 VDD VDD VSS VSS gf180mcu_as_sc_mcu7t3v3__fill_2
XTAP_TAPCELL_ROW_15_148 VDD VSS gf180mcu_as_sc_mcu7t3v3__tap_2
XFILLER_13_142 VDD VDD VSS VSS gf180mcu_as_sc_mcu7t3v3__fillcap_8
XTAP_TAPCELL_ROW_9_124 VDD VSS gf180mcu_as_sc_mcu7t3v3__tap_2
XFILLER_27_212 VDD VDD VSS VSS gf180mcu_as_sc_mcu7t3v3__fillcap_8
X_150_ VDD VDD VSS VSS _150_/D _150_/A _150_/B _150_/C _187_/D gf180mcu_as_sc_mcu7t3v3__ao31_2
XFILLER_38_2 VDD VDD VSS VSS gf180mcu_as_sc_mcu7t3v3__fillcap_16
XPHY_EDGE_ROW_25_Right_25 VDD VSS gf180mcu_as_sc_mcu7t3v3__tap_2
XPHY_EDGE_ROW_16_Right_16 VDD VSS gf180mcu_as_sc_mcu7t3v3__tap_2
XFILLER_5_2 VDD VDD VSS VSS gf180mcu_as_sc_mcu7t3v3__fillcap_16
XPHY_EDGE_ROW_34_Right_34 VDD VSS gf180mcu_as_sc_mcu7t3v3__tap_2
XFILLER_33_18 VDD VDD VSS VSS gf180mcu_as_sc_mcu7t3v3__fillcap_16
XFILLER_24_237 VDD VDD VSS VSS gf180mcu_as_sc_mcu7t3v3__fillcap_8
XTAP_TAPCELL_ROW_40_246 VDD VSS gf180mcu_as_sc_mcu7t3v3__tap_2
X_216__52 VDD VDD VSS VSS _216_/SN gf180mcu_as_sc_mcu7t3v3__tieh_4
XFILLER_15_248 VDD VDD VSS VSS gf180mcu_as_sc_mcu7t3v3__fillcap_16
X_202_ VDD VDD VSS VSS _205_/CLK _202_/Q _211_/RN _202_/SN _202_/D gf180mcu_as_sc_mcu7t3v3__dfsrtp_2
X_133_ VDD VDD VSS VSS _184_/Q _149_/B _148_/A _184_/D gf180mcu_as_sc_mcu7t3v3__mux2_2
XTAP_TAPCELL_ROW_31_213 VDD VSS gf180mcu_as_sc_mcu7t3v3__tap_2
XFILLER_28_18 VDD VDD VSS VSS gf180mcu_as_sc_mcu7t3v3__fillcap_16
X_116_ VDD VDD VSS VSS _146_/C _201_/Q gf180mcu_as_sc_mcu7t3v3__inv_2
XFILLER_7_244 VDD VDD VSS VSS gf180mcu_as_sc_mcu7t3v3__fillcap_16
XFILLER_29_104 VDD VDD VSS VSS gf180mcu_as_sc_mcu7t3v3__fillcap_16
XPHY_EDGE_ROW_2_Right_2 VDD VSS gf180mcu_as_sc_mcu7t3v3__tap_2
Xfanout5 VDD VDD VSS VSS _226_/RN _197_/RN gf180mcu_as_sc_mcu7t3v3__buff_2
XFILLER_29_72 VDD VDD VSS VSS gf180mcu_as_sc_mcu7t3v3__fillcap_16
XFILLER_20_96 VDD VDD VSS VSS gf180mcu_as_sc_mcu7t3v3__fillcap_8
X_201__14 VDD VDD VSS VSS _201_/SN gf180mcu_as_sc_mcu7t3v3__tieh_4
XFILLER_4_225 VDD VDD VSS VSS gf180mcu_as_sc_mcu7t3v3__fillcap_16
XFILLER_4_247 VDD VDD VSS VSS gf180mcu_as_sc_mcu7t3v3__fillcap_16
XFILLER_26_107 VDD VDD VSS VSS gf180mcu_as_sc_mcu7t3v3__fillcap_4
XFILLER_20_2 VDD VDD VSS VSS gf180mcu_as_sc_mcu7t3v3__fillcap_16
XFILLER_19_181 VDD VDD VSS VSS gf180mcu_as_sc_mcu7t3v3__fillcap_8
XPHY_EDGE_ROW_16_Left_57 VDD VSS gf180mcu_as_sc_mcu7t3v3__tap_2
XFILLER_1_228 VDD VDD VSS VSS gf180mcu_as_sc_mcu7t3v3__fillcap_16
XFILLER_1_206 VDD VDD VSS VSS gf180mcu_as_sc_mcu7t3v3__fillcap_4
XFILLER_40_154 VDD VDD VSS VSS gf180mcu_as_sc_mcu7t3v3__fillcap_16
XFILLER_25_195 VDD VDD VSS VSS gf180mcu_as_sc_mcu7t3v3__fill_2
XFILLER_39_276 VDD VDD VSS VSS gf180mcu_as_sc_mcu7t3v3__fillcap_4
XFILLER_36_18 VDD VDD VSS VSS gf180mcu_as_sc_mcu7t3v3__fillcap_16
XTAP_TAPCELL_ROW_26_190 VDD VSS gf180mcu_as_sc_mcu7t3v3__tap_2
XTAP_TAPCELL_ROW_9_125 VDD VSS gf180mcu_as_sc_mcu7t3v3__tap_2
XFILLER_36_279 VDD VDD VSS VSS gf180mcu_as_sc_mcu7t3v3__fillcap_8
XTAP_TAPCELL_ROW_15_149 VDD VSS gf180mcu_as_sc_mcu7t3v3__tap_2
XFILLER_3_88 VDD VDD VSS VSS gf180mcu_as_sc_mcu7t3v3__fillcap_16
XFILLER_3_66 VDD VDD VSS VSS gf180mcu_as_sc_mcu7t3v3__fillcap_4
XFILLER_9_136 VDD VDD VSS VSS gf180mcu_as_sc_mcu7t3v3__fillcap_4
XFILLER_35_290 VDD VDD VSS VSS gf180mcu_as_sc_mcu7t3v3__fill_2
XFILLER_27_224 VDD VDD VSS VSS gf180mcu_as_sc_mcu7t3v3__fill_2
XPHY_EDGE_ROW_19_Left_60 VDD VSS gf180mcu_as_sc_mcu7t3v3__tap_2
XFILLER_37_72 VDD VDD VSS VSS gf180mcu_as_sc_mcu7t3v3__fillcap_16
XFILLER_37_50 VDD VDD VSS VSS gf180mcu_as_sc_mcu7t3v3__fillcap_16
XFILLER_18_279 VDD VDD VSS VSS gf180mcu_as_sc_mcu7t3v3__fillcap_8
XFILLER_6_139 VDD VDD VSS VSS gf180mcu_as_sc_mcu7t3v3__fillcap_16
XTAP_TAPCELL_ROW_11_130 VDD VSS gf180mcu_as_sc_mcu7t3v3__tap_2
XTAP_TAPCELL_ROW_34_222 VDD VSS gf180mcu_as_sc_mcu7t3v3__tap_2
XFILLER_17_290 VDD VDD VSS VSS gf180mcu_as_sc_mcu7t3v3__fill_2
XTAP_TAPCELL_ROW_40_247 VDD VSS gf180mcu_as_sc_mcu7t3v3__tap_2
XFILLER_23_282 VDD VDD VSS VSS gf180mcu_as_sc_mcu7t3v3__fillcap_8
X_132_ VDD VDD VSS VSS _148_/A _213_/D _138_/B gf180mcu_as_sc_mcu7t3v3__nor2b_2
XFILLER_15_216 VDD VDD VSS VSS gf180mcu_as_sc_mcu7t3v3__fillcap_16
Xclkbuf_3_0__f_clk_i VDD VDD VSS VSS clkbuf_0_clk_i/Y _219_/CLK gf180mcu_as_sc_mcu7t3v3__clkbuff_12
X_201_ VDD VDD VSS VSS _205_/CLK _201_/Q _211_/RN _201_/SN _201_/D gf180mcu_as_sc_mcu7t3v3__dfsrtp_2
XPHY_EDGE_ROW_4_Left_45 VDD VSS gf180mcu_as_sc_mcu7t3v3__tap_2
X_222__45 VDD VDD VSS VSS _222_/SN gf180mcu_as_sc_mcu7t3v3__tieh_4
XFILLER_20_263 VDD VDD VSS VSS gf180mcu_as_sc_mcu7t3v3__fillcap_16
X_115_ VDD VDD VSS VSS _146_/B _200_/Q gf180mcu_as_sc_mcu7t3v3__inv_2
XFILLER_7_212 VDD VDD VSS VSS gf180mcu_as_sc_mcu7t3v3__fillcap_16
XFILLER_39_18 VDD VDD VSS VSS gf180mcu_as_sc_mcu7t3v3__fillcap_16
XFILLER_28_193 VDD VDD VSS VSS gf180mcu_as_sc_mcu7t3v3__fillcap_16
XFILLER_20_64 VDD VDD VSS VSS gf180mcu_as_sc_mcu7t3v3__fillcap_16
XFILLER_20_53 VDD VDD VSS VSS gf180mcu_as_sc_mcu7t3v3__fill_1
XFILLER_13_2 VDD VDD VSS VSS gf180mcu_as_sc_mcu7t3v3__fillcap_16
XFILLER_40_188 VDD VDD VSS VSS gf180mcu_as_sc_mcu7t3v3__fillcap_16
XPHY_EDGE_ROW_33_Left_74 VDD VSS gf180mcu_as_sc_mcu7t3v3__tap_2
XTAP_TAPCELL_ROW_26_191 VDD VSS gf180mcu_as_sc_mcu7t3v3__tap_2
XTAP_TAPCELL_ROW_18_158 VDD VSS gf180mcu_as_sc_mcu7t3v3__tap_2
XFILLER_16_174 VDD VDD VSS VSS gf180mcu_as_sc_mcu7t3v3__fill_1
XFILLER_0_240 VDD VDD VSS VSS gf180mcu_as_sc_mcu7t3v3__fillcap_16
.ends
