* NGSPICE file created from ring_osc2x13.ext - technology: gf180mcuD

* Black-box entry subcircuit for gf180mcu_fd_sc_mcu7t5v0__fillcap_4 abstract view
.subckt gf180mcu_fd_sc_mcu7t5v0__fillcap_4 VDD VNW VPW VSS
.ends

* Black-box entry subcircuit for gf180mcu_fd_sc_mcu7t5v0__fill_1 abstract view
.subckt gf180mcu_fd_sc_mcu7t5v0__fill_1 VDD VNW VPW VSS
.ends

* Black-box entry subcircuit for gf180mcu_fd_sc_mcu7t5v0__fill_2 abstract view
.subckt gf180mcu_fd_sc_mcu7t5v0__fill_2 VDD VNW VPW VSS
.ends

* Black-box entry subcircuit for gf180mcu_fd_sc_mcu7t5v0__latrnq_1 abstract view
.subckt gf180mcu_fd_sc_mcu7t5v0__latrnq_1 D E RN Q VDD VNW VPW VSS
.ends

* Black-box entry subcircuit for gf180mcu_fd_sc_mcu7t5v0__fillcap_8 abstract view
.subckt gf180mcu_fd_sc_mcu7t5v0__fillcap_8 VDD VNW VPW VSS
.ends

* Black-box entry subcircuit for gf180mcu_fd_sc_mcu7t5v0__filltie abstract view
.subckt gf180mcu_fd_sc_mcu7t5v0__filltie VDD VSS
.ends

* Black-box entry subcircuit for gf180mcu_fd_sc_mcu7t5v0__invz_8 abstract view
.subckt gf180mcu_fd_sc_mcu7t5v0__invz_8 EN I ZN VDD VNW VPW VSS
.ends

* Black-box entry subcircuit for gf180mcu_fd_sc_mcu7t5v0__invz_2 abstract view
.subckt gf180mcu_fd_sc_mcu7t5v0__invz_2 EN I ZN VDD VNW VPW VSS
.ends

* Black-box entry subcircuit for gf180mcu_fd_sc_mcu7t5v0__fillcap_16 abstract view
.subckt gf180mcu_fd_sc_mcu7t5v0__fillcap_16 VDD VNW VPW VSS
.ends

* Black-box entry subcircuit for gf180mcu_fd_sc_mcu7t5v0__hold abstract view
.subckt gf180mcu_fd_sc_mcu7t5v0__hold Z VDD VNW VPW VSS
.ends

* Black-box entry subcircuit for gf180mcu_fd_sc_mcu7t5v0__clkbuf_2 abstract view
.subckt gf180mcu_fd_sc_mcu7t5v0__clkbuf_2 I Z VDD VNW VPW VSS
.ends

* Black-box entry subcircuit for gf180mcu_fd_sc_mcu7t5v0__inv_1 abstract view
.subckt gf180mcu_fd_sc_mcu7t5v0__inv_1 I ZN VDD VNW VPW VSS
.ends

* Black-box entry subcircuit for gf180mcu_fd_sc_mcu7t5v0__xor2_1 abstract view
.subckt gf180mcu_fd_sc_mcu7t5v0__xor2_1 A1 A2 Z VDD VNW VPW VSS
.ends

* Black-box entry subcircuit for gf180mcu_fd_sc_mcu7t5v0__endcap abstract view
.subckt gf180mcu_fd_sc_mcu7t5v0__endcap VDD VSS
.ends

* Black-box entry subcircuit for gf180mcu_fd_sc_mcu7t5v0__invz_4 abstract view
.subckt gf180mcu_fd_sc_mcu7t5v0__invz_4 EN I ZN VDD VNW VPW VSS
.ends

* Black-box entry subcircuit for gf180mcu_fd_sc_mcu7t5v0__and2_2 abstract view
.subckt gf180mcu_fd_sc_mcu7t5v0__and2_2 A1 A2 Z VDD VNW VPW VSS
.ends

* Black-box entry subcircuit for gf180mcu_fd_sc_mcu7t5v0__antenna abstract view
.subckt gf180mcu_fd_sc_mcu7t5v0__antenna I VDD VNW VPW VSS
.ends

* Black-box entry subcircuit for gf180mcu_fd_sc_mcu7t5v0__clkbuf_1 abstract view
.subckt gf180mcu_fd_sc_mcu7t5v0__clkbuf_1 I Z VDD VNW VPW VSS
.ends

* Black-box entry subcircuit for gf180mcu_fd_sc_mcu7t5v0__clkinv_2 abstract view
.subckt gf180mcu_fd_sc_mcu7t5v0__clkinv_2 I ZN VDD VNW VPW VSS
.ends

* Black-box entry subcircuit for gf180mcu_fd_sc_mcu7t5v0__tieh abstract view
.subckt gf180mcu_fd_sc_mcu7t5v0__tieh Z VDD VNW VPW VSS
.ends

* Black-box entry subcircuit for gf180mcu_fd_sc_mcu7t5v0__invz_1 abstract view
.subckt gf180mcu_fd_sc_mcu7t5v0__invz_1 EN I ZN VDD VNW VPW VSS
.ends

* Black-box entry subcircuit for gf180mcu_fd_sc_mcu7t5v0__nor2_2 abstract view
.subckt gf180mcu_fd_sc_mcu7t5v0__nor2_2 A1 A2 ZN VDD VNW VPW VSS
.ends

* Black-box entry subcircuit for gf180mcu_fd_sc_mcu7t5v0__clkinv_1 abstract view
.subckt gf180mcu_fd_sc_mcu7t5v0__clkinv_1 I ZN VDD VNW VPW VSS
.ends

* Black-box entry subcircuit for gf180mcu_fd_sc_mcu7t5v0__dlyb_1 abstract view
.subckt gf180mcu_fd_sc_mcu7t5v0__dlyb_1 I Z VDD VNW VPW VSS
.ends

* Black-box entry subcircuit for gf180mcu_fd_sc_mcu7t5v0__clkinv_8 abstract view
.subckt gf180mcu_fd_sc_mcu7t5v0__clkinv_8 I ZN VDD VNW VPW VSS
.ends

* Black-box entry subcircuit for gf180mcu_fd_sc_mcu7t5v0__inv_2 abstract view
.subckt gf180mcu_fd_sc_mcu7t5v0__inv_2 I ZN VDD VNW VPW VSS
.ends

.subckt ring_osc2x13 VDD VSS clockp[0] clockp[1] reset trim[0] trim[10] trim[11] trim[12]
+ trim[13] trim[14] trim[15] trim[16] trim[17] trim[18] trim[19] trim[1] trim[20]
+ trim[21] trim[22] trim[23] trim[24] trim[25] trim[2] trim[3] trim[4] trim[5] trim[6]
+ trim[7] trim[8] trim[9]
XFILLER_9_148 VDD VDD VSS VSS gf180mcu_fd_sc_mcu7t5v0__fillcap_4
XFILLER_9_115 VDD VDD VSS VSS gf180mcu_fd_sc_mcu7t5v0__fill_1
XFILLER_10_103 VDD VDD VSS VSS gf180mcu_fd_sc_mcu7t5v0__fill_2
Xdstage\[10\].id.t0_latch trim[10] dstage\[10\].id.not_edge dstage\[10\].id.nreset
+ dstage\[10\].id.ltrim\[0\] VDD VDD VSS VSS gf180mcu_fd_sc_mcu7t5v0__latrnq_1
XFILLER_2_143 VDD VDD VSS VSS gf180mcu_fd_sc_mcu7t5v0__fillcap_8
XTAP_TAPCELL_ROW_5_56 VDD VSS gf180mcu_fd_sc_mcu7t5v0__filltie
Xdstage\[2\].id.t1_latch trim[15] dstage\[2\].id.not_edge dstage\[10\].id.nreset dstage\[2\].id.ltrim\[1\]
+ VDD VDD VSS VSS gf180mcu_fd_sc_mcu7t5v0__latrnq_1
XTAP_TAPCELL_ROW_20_87 VDD VSS gf180mcu_fd_sc_mcu7t5v0__filltie
XFILLER_19_150 VDD VDD VSS VSS gf180mcu_fd_sc_mcu7t5v0__fillcap_4
Xdstage\[8\].id.delayenb0 dstage\[8\].id.ltrimb\[0\] dstage\[8\].id.ts dstage\[11\].id.prev_in
+ VDD VDD VSS VSS gf180mcu_fd_sc_mcu7t5v0__invz_8
Xdstage\[5\].id.delayen0 dstage\[5\].id.ltrim\[0\] dstage\[5\].id.d2 dstage\[5\].id.out
+ VDD VDD VSS VSS gf180mcu_fd_sc_mcu7t5v0__invz_2
XTAP_TAPCELL_ROW_15_76 VDD VSS gf180mcu_fd_sc_mcu7t5v0__filltie
XFILLER_16_153 VDD VDD VSS VSS gf180mcu_fd_sc_mcu7t5v0__fill_1
XFILLER_16_131 VDD VDD VSS VSS gf180mcu_fd_sc_mcu7t5v0__fillcap_16
Xdstage\[5\].id.hold_d1 dstage\[5\].id.d1 VDD VDD VSS VSS gf180mcu_fd_sc_mcu7t5v0__hold
Xdstage\[4\].id.deglitch_buf dstage\[4\].id.out dstage\[4\].id.out_del VDD VDD VSS
+ VSS gf180mcu_fd_sc_mcu7t5v0__clkbuf_2
Xdstage\[5\].id.trim1bar dstage\[5\].id.ltrim\[1\] dstage\[5\].id.ltrimb\[1\] VDD
+ VDD VSS VSS gf180mcu_fd_sc_mcu7t5v0__inv_1
Xdstage\[7\].id.trim_inhibit dstage\[4\].id.out dstage\[7\].id.out_del dstage\[7\].id.not_edge
+ VDD VDD VSS VSS gf180mcu_fd_sc_mcu7t5v0__xor2_1
XPHY_EDGE_ROW_21_Right_21 VDD VSS gf180mcu_fd_sc_mcu7t5v0__endcap
XPHY_EDGE_ROW_12_Right_12 VDD VSS gf180mcu_fd_sc_mcu7t5v0__endcap
XFILLER_0_25 VDD VDD VSS VSS gf180mcu_fd_sc_mcu7t5v0__fill_1
XTAP_TAPCELL_ROW_5_57 VDD VSS gf180mcu_fd_sc_mcu7t5v0__filltie
XPHY_EDGE_ROW_16_Left_38 VDD VSS gf180mcu_fd_sc_mcu7t5v0__endcap
Xdstage\[8\].id.delayenb1 dstage\[8\].id.ltrimb\[1\] dstage\[8\].id.ts dstage\[8\].id.d1
+ VDD VDD VSS VSS gf180mcu_fd_sc_mcu7t5v0__invz_4
Xdstage\[5\].id.delayen1 dstage\[5\].id.ltrim\[1\] dstage\[5\].id.d0 dstage\[5\].id.d1
+ VDD VDD VSS VSS gf180mcu_fd_sc_mcu7t5v0__invz_2
XTAP_TAPCELL_ROW_15_77 VDD VSS gf180mcu_fd_sc_mcu7t5v0__filltie
XPHY_EDGE_ROW_6_Right_6 VDD VSS gf180mcu_fd_sc_mcu7t5v0__endcap
Xdstage\[11\].id.delayenb0 dstage\[11\].id.ltrimb\[0\] dstage\[11\].id.ts dstage\[11\].id.out
+ VDD VDD VSS VSS gf180mcu_fd_sc_mcu7t5v0__invz_8
XFILLER_16_121 VDD VDD VSS VSS gf180mcu_fd_sc_mcu7t5v0__fill_1
Xdstage\[2\].id.t0_latch trim[2] dstage\[2\].id.not_edge dstage\[10\].id.nreset dstage\[2\].id.ltrim\[0\]
+ VDD VDD VSS VSS gf180mcu_fd_sc_mcu7t5v0__latrnq_1
Xiss.delayenb0 iss.ctrl0b dstage\[11\].id.out iss.out_precg VDD VDD VSS VSS gf180mcu_fd_sc_mcu7t5v0__invz_8
XFILLER_10_116 VDD VDD VSS VSS gf180mcu_fd_sc_mcu7t5v0__fill_1
XPHY_EDGE_ROW_19_Left_41 VDD VSS gf180mcu_fd_sc_mcu7t5v0__endcap
XFILLER_5_142 VDD VDD VSS VSS gf180mcu_fd_sc_mcu7t5v0__fillcap_8
Xdstage\[4\].id.trim0bar dstage\[4\].id.ltrim\[0\] dstage\[4\].id.ltrimb\[0\] VDD
+ VDD VSS VSS gf180mcu_fd_sc_mcu7t5v0__inv_1
XPHY_EDGE_ROW_4_Left_26 VDD VSS gf180mcu_fd_sc_mcu7t5v0__endcap
XFILLER_20_34 VDD VDD VSS VSS gf180mcu_fd_sc_mcu7t5v0__fill_1
XFILLER_6_25 VDD VDD VSS VSS gf180mcu_fd_sc_mcu7t5v0__fill_1
Xdstage\[11\].id.delayenb1 dstage\[11\].id.ltrimb\[1\] dstage\[11\].id.ts dstage\[11\].id.d1
+ VDD VDD VSS VSS gf180mcu_fd_sc_mcu7t5v0__invz_4
Xdstage\[8\].id.delaybuf0 dstage\[10\].id.prev_in dstage\[8\].id.ts VDD VDD VSS VSS
+ gf180mcu_fd_sc_mcu7t5v0__clkbuf_2
Xiss.cg_and iss.out_precg iss.nreset_del dstage\[2\].id.prev_in VDD VDD VSS VSS gf180mcu_fd_sc_mcu7t5v0__and2_2
Xdstage\[4\].id.delayenb0 dstage\[4\].id.ltrimb\[0\] dstage\[4\].id.ts dstage\[4\].id.out
+ VDD VDD VSS VSS gf180mcu_fd_sc_mcu7t5v0__invz_8
XANTENNA_id0.t1_latch_D trim[13] VDD VDD VSS VSS gf180mcu_fd_sc_mcu7t5v0__antenna
Xiss.delayenb1 iss.trim1b dstage\[11\].id.out iss.d1 VDD VDD VSS VSS gf180mcu_fd_sc_mcu7t5v0__invz_4
Xdstage\[10\].id.delayen0 dstage\[10\].id.ltrim\[0\] dstage\[10\].id.d2 dstage\[10\].id.out
+ VDD VDD VSS VSS gf180mcu_fd_sc_mcu7t5v0__invz_2
XPHY_EDGE_ROW_20_Left_42 VDD VSS gf180mcu_fd_sc_mcu7t5v0__endcap
XANTENNA_dstage\[8\].id.t1_latch_D trim[21] VDD VDD VSS VSS gf180mcu_fd_sc_mcu7t5v0__antenna
Xdstage\[10\].id.trim1bar dstage\[10\].id.ltrim\[1\] dstage\[10\].id.ltrimb\[1\] VDD
+ VDD VSS VSS gf180mcu_fd_sc_mcu7t5v0__inv_1
XFILLER_19_142 VDD VDD VSS VSS gf180mcu_fd_sc_mcu7t5v0__fillcap_8
Xdstage\[8\].id.delaybuf1 dstage\[8\].id.ts dstage\[8\].id.d0 VDD VDD VSS VSS gf180mcu_fd_sc_mcu7t5v0__clkbuf_1
Xdstage\[4\].id.delayenb1 dstage\[4\].id.ltrimb\[1\] dstage\[4\].id.ts dstage\[4\].id.d1
+ VDD VDD VSS VSS gf180mcu_fd_sc_mcu7t5v0__invz_4
XFILLER_13_148 VDD VDD VSS VSS gf180mcu_fd_sc_mcu7t5v0__fillcap_4
Xdstage\[11\].id.delaybuf0 dstage\[10\].id.out dstage\[11\].id.ts VDD VDD VSS VSS
+ gf180mcu_fd_sc_mcu7t5v0__clkbuf_2
XFILLER_8_152 VDD VDD VSS VSS gf180mcu_fd_sc_mcu7t5v0__fill_2
Xdstage\[10\].id.delayen1 dstage\[10\].id.ltrim\[1\] dstage\[10\].id.d0 dstage\[10\].id.d1
+ VDD VDD VSS VSS gf180mcu_fd_sc_mcu7t5v0__invz_2
Xiss.delaybuf0 dstage\[11\].id.out iss.d0 VDD VDD VSS VSS gf180mcu_fd_sc_mcu7t5v0__clkbuf_1
Xdstage\[2\].id.trim_inhibit dstage\[2\].id.prev_in dstage\[2\].id.out_del dstage\[2\].id.not_edge
+ VDD VDD VSS VSS gf180mcu_fd_sc_mcu7t5v0__xor2_1
XFILLER_1_2 VDD VDD VSS VSS gf180mcu_fd_sc_mcu7t5v0__fill_1
Xdstage\[2\].id.delayen0 dstage\[2\].id.ltrim\[0\] dstage\[2\].id.d2 dstage\[2\].id.out
+ VDD VDD VSS VSS gf180mcu_fd_sc_mcu7t5v0__invz_2
XFILLER_15_69 VDD VDD VSS VSS gf180mcu_fd_sc_mcu7t5v0__fill_1
XTAP_TAPCELL_ROW_21_90 VDD VSS gf180mcu_fd_sc_mcu7t5v0__filltie
XPHY_EDGE_ROW_19_Right_19 VDD VSS gf180mcu_fd_sc_mcu7t5v0__endcap
Xid1.hold_out dstage\[2\].id.in VDD VDD VSS VSS gf180mcu_fd_sc_mcu7t5v0__hold
Xdstage\[7\].id.hold_out dstage\[10\].id.prev_in VDD VDD VSS VSS gf180mcu_fd_sc_mcu7t5v0__hold
Xdstage\[2\].id.trim1bar dstage\[2\].id.ltrim\[1\] dstage\[2\].id.ltrimb\[1\] VDD
+ VDD VSS VSS gf180mcu_fd_sc_mcu7t5v0__inv_1
Xdstage\[11\].id.delaybuf1 dstage\[11\].id.ts dstage\[11\].id.d0 VDD VDD VSS VSS gf180mcu_fd_sc_mcu7t5v0__clkbuf_1
XFILLER_12_37 VDD VDD VSS VSS gf180mcu_fd_sc_mcu7t5v0__fill_1
XANTENNA_dstage\[3\].id.t1_latch_D trim[16] VDD VDD VSS VSS gf180mcu_fd_sc_mcu7t5v0__antenna
Xdstage\[4\].id.delaybuf0 dstage\[3\].id.out dstage\[4\].id.ts VDD VDD VSS VSS gf180mcu_fd_sc_mcu7t5v0__clkbuf_2
XFILLER_5_134 VDD VDD VSS VSS gf180mcu_fd_sc_mcu7t5v0__fillcap_4
Xdstage\[7\].id.delayint0 dstage\[7\].id.d1 dstage\[7\].id.d2 VDD VDD VSS VSS gf180mcu_fd_sc_mcu7t5v0__clkinv_2
Xdstage\[2\].id.delayen1 dstage\[2\].id.ltrim\[1\] dstage\[2\].id.d0 dstage\[2\].id.d1
+ VDD VDD VSS VSS gf180mcu_fd_sc_mcu7t5v0__invz_2
XANTENNA_dstage\[7\].id.t0_latch_D trim[7] VDD VDD VSS VSS gf180mcu_fd_sc_mcu7t5v0__antenna
XTAP_TAPCELL_ROW_21_91 VDD VSS gf180mcu_fd_sc_mcu7t5v0__filltie
XFILLER_16_147 VDD VDD VSS VSS gf180mcu_fd_sc_mcu7t5v0__fillcap_4
XFILLER_13_139 VDD VDD VSS VSS gf180mcu_fd_sc_mcu7t5v0__fill_1
Xdstage\[7\].id.t1_latch trim[20] dstage\[7\].id.not_edge dstage\[10\].id.nreset dstage\[7\].id.ltrim\[1\]
+ VDD VDD VSS VSS gf180mcu_fd_sc_mcu7t5v0__latrnq_1
Xid1.t1_latch trim[14] id1.not_edge dstage\[10\].id.nreset id1.ltrim\[1\] VDD VDD
+ VSS VSS gf180mcu_fd_sc_mcu7t5v0__latrnq_1
Xdstage\[7\].id.deglitch_buf dstage\[10\].id.prev_in dstage\[7\].id.out_del VDD VDD
+ VSS VSS gf180mcu_fd_sc_mcu7t5v0__clkbuf_2
Xdstage\[4\].id.delaybuf1 dstage\[4\].id.ts dstage\[4\].id.d0 VDD VDD VSS VSS gf180mcu_fd_sc_mcu7t5v0__clkbuf_1
Xdstage\[10\].id.delayint0 dstage\[10\].id.d1 dstage\[10\].id.d2 VDD VDD VSS VSS gf180mcu_fd_sc_mcu7t5v0__clkinv_2
XPHY_EDGE_ROW_11_Left_33 VDD VSS gf180mcu_fd_sc_mcu7t5v0__endcap
XPHY_EDGE_ROW_1_Right_1 VDD VSS gf180mcu_fd_sc_mcu7t5v0__endcap
XFILLER_7_72 VDD VDD VSS VSS gf180mcu_fd_sc_mcu7t5v0__fill_1
Xid1.t0_latch trim[1] id1.not_edge dstage\[10\].id.nreset id1.ltrim\[0\] VDD VDD VSS
+ VSS gf180mcu_fd_sc_mcu7t5v0__latrnq_1
Xdstage\[7\].id.t0_latch trim[7] dstage\[7\].id.not_edge dstage\[10\].id.nreset dstage\[7\].id.ltrim\[0\]
+ VDD VDD VSS VSS gf180mcu_fd_sc_mcu7t5v0__latrnq_1
XFILLER_1_150 VDD VDD VSS VSS gf180mcu_fd_sc_mcu7t5v0__fillcap_4
Xdstage\[3\].id.delayint0 dstage\[3\].id.d1 dstage\[3\].id.d2 VDD VDD VSS VSS gf180mcu_fd_sc_mcu7t5v0__clkinv_2
XANTENNA_dstage\[2\].id.t0_latch_D trim[2] VDD VDD VSS VSS gf180mcu_fd_sc_mcu7t5v0__antenna
Xdstage\[9\].id.trim0bar dstage\[9\].id.ltrim\[0\] dstage\[9\].id.ltrimb\[0\] VDD
+ VDD VSS VSS gf180mcu_fd_sc_mcu7t5v0__inv_1
XFILLER_15_39 VDD VDD VSS VSS gf180mcu_fd_sc_mcu7t5v0__fill_1
XPHY_EDGE_ROW_15_Right_15 VDD VSS gf180mcu_fd_sc_mcu7t5v0__endcap
XTAP_TAPCELL_ROW_3_52 VDD VSS gf180mcu_fd_sc_mcu7t5v0__filltie
Xdstage\[6\].id.hold_d1 dstage\[6\].id.d1 VDD VDD VSS VSS gf180mcu_fd_sc_mcu7t5v0__hold
XTAP_TAPCELL_ROW_13_72 VDD VSS gf180mcu_fd_sc_mcu7t5v0__filltie
Xid0.hold_d1 id0.d1 VDD VDD VSS VSS gf180mcu_fd_sc_mcu7t5v0__hold
XFILLER_15_150 VDD VDD VSS VSS gf180mcu_fd_sc_mcu7t5v0__fillcap_4
XANTENNA_id1.t0_latch_D trim[1] VDD VDD VSS VSS gf180mcu_fd_sc_mcu7t5v0__antenna
Xid0.trim0bar id0.ltrim\[0\] id0.ltrimb\[0\] VDD VDD VSS VSS gf180mcu_fd_sc_mcu7t5v0__inv_1
Xdstage\[4\].id.hold_out dstage\[4\].id.out VDD VDD VSS VSS gf180mcu_fd_sc_mcu7t5v0__hold
XTAP_TAPCELL_ROW_3_53 VDD VSS gf180mcu_fd_sc_mcu7t5v0__filltie
XFILLER_5_138 VDD VDD VSS VSS gf180mcu_fd_sc_mcu7t5v0__fill_2
XTAP_TAPCELL_ROW_13_73 VDD VSS gf180mcu_fd_sc_mcu7t5v0__filltie
Xdstage\[2\].id.deglitch_buf dstage\[2\].id.out dstage\[2\].id.out_del VDD VDD VSS
+ VSS gf180mcu_fd_sc_mcu7t5v0__clkbuf_2
Xdstage\[5\].id.trim_inhibit dstage\[2\].id.out dstage\[5\].id.out_del dstage\[5\].id.not_edge
+ VDD VDD VSS VSS gf180mcu_fd_sc_mcu7t5v0__xor2_1
XFILLER_21_84 VDD VDD VSS VSS gf180mcu_fd_sc_mcu7t5v0__fill_1
XPHY_EDGE_ROW_15_Left_37 VDD VSS gf180mcu_fd_sc_mcu7t5v0__endcap
Xdstage\[4\].id.t1_latch trim[17] dstage\[4\].id.not_edge dstage\[10\].id.nreset dstage\[4\].id.ltrim\[1\]
+ VDD VDD VSS VSS gf180mcu_fd_sc_mcu7t5v0__latrnq_1
XPHY_EDGE_ROW_5_Right_5 VDD VSS gf180mcu_fd_sc_mcu7t5v0__endcap
Xid1.delayen0 id1.ltrim\[0\] id1.d2 dstage\[2\].id.in VDD VDD VSS VSS gf180mcu_fd_sc_mcu7t5v0__invz_2
Xdstage\[7\].id.delayen0 dstage\[7\].id.ltrim\[0\] dstage\[7\].id.d2 dstage\[10\].id.prev_in
+ VDD VDD VSS VSS gf180mcu_fd_sc_mcu7t5v0__invz_2
Xdstage\[7\].id.delayenb0 dstage\[7\].id.ltrimb\[0\] dstage\[7\].id.ts dstage\[10\].id.prev_in
+ VDD VDD VSS VSS gf180mcu_fd_sc_mcu7t5v0__invz_8
XANTENNA_dstage\[9\].id.t1_latch_D trim[22] VDD VDD VSS VSS gf180mcu_fd_sc_mcu7t5v0__antenna
XTAP_TAPCELL_ROW_0_44 VDD VSS gf180mcu_fd_sc_mcu7t5v0__filltie
XPHY_EDGE_ROW_18_Left_40 VDD VSS gf180mcu_fd_sc_mcu7t5v0__endcap
XFILLER_1_142 VDD VDD VSS VSS gf180mcu_fd_sc_mcu7t5v0__fillcap_8
XTAP_TAPCELL_ROW_9_64 VDD VSS gf180mcu_fd_sc_mcu7t5v0__filltie
Xid1.trim1bar id1.ltrim\[1\] id1.ltrimb\[1\] VDD VDD VSS VSS gf180mcu_fd_sc_mcu7t5v0__inv_1
XPHY_EDGE_ROW_3_Left_25 VDD VSS gf180mcu_fd_sc_mcu7t5v0__endcap
Xdstage\[7\].id.trim1bar dstage\[7\].id.ltrim\[1\] dstage\[7\].id.ltrimb\[1\] VDD
+ VDD VSS VSS gf180mcu_fd_sc_mcu7t5v0__inv_1
Xiss.reseten0_1 net VDD VDD VSS VSS gf180mcu_fd_sc_mcu7t5v0__tieh
Xdstage\[10\].id.trim_inhibit dstage\[10\].id.prev_in dstage\[10\].id.out_del dstage\[10\].id.not_edge
+ VDD VDD VSS VSS gf180mcu_fd_sc_mcu7t5v0__xor2_1
XTAP_TAPCELL_ROW_19_84 VDD VSS gf180mcu_fd_sc_mcu7t5v0__filltie
Xiss.reseten0 reset net iss.out_precg VDD VDD VSS VSS gf180mcu_fd_sc_mcu7t5v0__invz_1
XFILLER_21_133 VDD VDD VSS VSS gf180mcu_fd_sc_mcu7t5v0__fill_2
XPHY_EDGE_ROW_20_Right_20 VDD VSS gf180mcu_fd_sc_mcu7t5v0__endcap
XPHY_EDGE_ROW_11_Right_11 VDD VSS gf180mcu_fd_sc_mcu7t5v0__endcap
Xid1.delayen1 id1.ltrim\[1\] id1.d0 id1.d1 VDD VDD VSS VSS gf180mcu_fd_sc_mcu7t5v0__invz_2
Xdstage\[7\].id.delayen1 dstage\[7\].id.ltrim\[1\] dstage\[7\].id.d0 dstage\[7\].id.d1
+ VDD VDD VSS VSS gf180mcu_fd_sc_mcu7t5v0__invz_2
Xdstage\[4\].id.t0_latch trim[4] dstage\[4\].id.not_edge dstage\[10\].id.nreset dstage\[4\].id.ltrim\[0\]
+ VDD VDD VSS VSS gf180mcu_fd_sc_mcu7t5v0__latrnq_1
Xdstage\[7\].id.delayenb1 dstage\[7\].id.ltrimb\[1\] dstage\[7\].id.ts dstage\[7\].id.d1
+ VDD VDD VSS VSS gf180mcu_fd_sc_mcu7t5v0__invz_4
Xdstage\[10\].id.delayenb0 dstage\[10\].id.ltrimb\[0\] dstage\[10\].id.ts dstage\[10\].id.out
+ VDD VDD VSS VSS gf180mcu_fd_sc_mcu7t5v0__invz_8
XTAP_TAPCELL_ROW_9_65 VDD VSS gf180mcu_fd_sc_mcu7t5v0__filltie
XTAP_TAPCELL_ROW_0_45 VDD VSS gf180mcu_fd_sc_mcu7t5v0__filltie
XFILLER_8_2 VDD VDD VSS VSS gf180mcu_fd_sc_mcu7t5v0__fill_1
Xid1.delayint0 id1.d1 id1.d2 VDD VDD VSS VSS gf180mcu_fd_sc_mcu7t5v0__clkinv_2
Xdstage\[6\].id.trim0bar dstage\[6\].id.ltrim\[0\] dstage\[6\].id.ltrimb\[0\] VDD
+ VDD VSS VSS gf180mcu_fd_sc_mcu7t5v0__inv_1
XFILLER_10_76 VDD VDD VSS VSS gf180mcu_fd_sc_mcu7t5v0__fill_1
XTAP_TAPCELL_ROW_19_85 VDD VSS gf180mcu_fd_sc_mcu7t5v0__filltie
XFILLER_19_139 VDD VDD VSS VSS gf180mcu_fd_sc_mcu7t5v0__fill_1
XFILLER_18_4 VDD VDD VSS VSS gf180mcu_fd_sc_mcu7t5v0__fill_1
XFILLER_15_142 VDD VDD VSS VSS gf180mcu_fd_sc_mcu7t5v0__fillcap_8
XANTENNA_dstage\[4\].id.t1_latch_D trim[17] VDD VDD VSS VSS gf180mcu_fd_sc_mcu7t5v0__antenna
XANTENNA_id0.t0_latch_D trim[0] VDD VDD VSS VSS gf180mcu_fd_sc_mcu7t5v0__antenna
XFILLER_4_78 VDD VDD VSS VSS gf180mcu_fd_sc_mcu7t5v0__fill_1
Xdstage\[10\].id.delayenb1 dstage\[10\].id.ltrimb\[1\] dstage\[10\].id.ts dstage\[10\].id.d1
+ VDD VDD VSS VSS gf180mcu_fd_sc_mcu7t5v0__invz_4
XTAP_TAPCELL_ROW_0_46 VDD VSS gf180mcu_fd_sc_mcu7t5v0__filltie
Xid0.trim_inhibit dstage\[10\].id.out id0.out_del id0.not_edge VDD VDD VSS VSS gf180mcu_fd_sc_mcu7t5v0__xor2_1
Xdstage\[7\].id.delaybuf0 dstage\[6\].id.out dstage\[7\].id.ts VDD VDD VSS VSS gf180mcu_fd_sc_mcu7t5v0__clkbuf_2
Xdstage\[3\].id.delayenb0 dstage\[3\].id.ltrimb\[0\] dstage\[3\].id.ts dstage\[3\].id.out
+ VDD VDD VSS VSS gf180mcu_fd_sc_mcu7t5v0__invz_8
XFILLER_1_35 VDD VDD VSS VSS gf180mcu_fd_sc_mcu7t5v0__fill_1
XANTENNA_dstage\[8\].id.t0_latch_D trim[8] VDD VDD VSS VSS gf180mcu_fd_sc_mcu7t5v0__antenna
XTAP_TAPCELL_ROW_10_66 VDD VSS gf180mcu_fd_sc_mcu7t5v0__filltie
XFILLER_15_132 VDD VDD VSS VSS gf180mcu_fd_sc_mcu7t5v0__fillcap_8
XFILLER_21_135 VDD VDD VSS VSS gf180mcu_fd_sc_mcu7t5v0__fill_1
XFILLER_16_2 VDD VDD VSS VSS gf180mcu_fd_sc_mcu7t5v0__fill_1
XFILLER_12_146 VDD VDD VSS VSS gf180mcu_fd_sc_mcu7t5v0__fillcap_8
XPHY_EDGE_ROW_9_Right_9 VDD VSS gf180mcu_fd_sc_mcu7t5v0__endcap
XFILLER_7_150 VDD VDD VSS VSS gf180mcu_fd_sc_mcu7t5v0__fillcap_4
XTAP_TAPCELL_ROW_0_47 VDD VSS gf180mcu_fd_sc_mcu7t5v0__filltie
Xdstage\[7\].id.delaybuf1 dstage\[7\].id.ts dstage\[7\].id.d0 VDD VDD VSS VSS gf180mcu_fd_sc_mcu7t5v0__clkbuf_1
Xdstage\[3\].id.delayenb1 dstage\[3\].id.ltrimb\[1\] dstage\[3\].id.ts dstage\[3\].id.d1
+ VDD VDD VSS VSS gf180mcu_fd_sc_mcu7t5v0__invz_4
Xdstage\[10\].id.delaybuf0 dstage\[10\].id.in dstage\[10\].id.ts VDD VDD VSS VSS gf180mcu_fd_sc_mcu7t5v0__clkbuf_2
XTAP_TAPCELL_ROW_10_67 VDD VSS gf180mcu_fd_sc_mcu7t5v0__filltie
XPHY_EDGE_ROW_7_Left_29 VDD VSS gf180mcu_fd_sc_mcu7t5v0__endcap
XFILLER_19_87 VDD VDD VSS VSS gf180mcu_fd_sc_mcu7t5v0__fill_1
XTAP_TAPCELL_ROW_21_88 VDD VSS gf180mcu_fd_sc_mcu7t5v0__filltie
XFILLER_18_152 VDD VDD VSS VSS gf180mcu_fd_sc_mcu7t5v0__fill_2
XFILLER_21_33 VDD VDD VSS VSS gf180mcu_fd_sc_mcu7t5v0__fill_1
XFILLER_12_103 VDD VDD VSS VSS gf180mcu_fd_sc_mcu7t5v0__fill_2
XFILLER_21_125 VDD VDD VSS VSS gf180mcu_fd_sc_mcu7t5v0__fillcap_8
Xdstage\[4\].id.delayen0 dstage\[4\].id.ltrim\[0\] dstage\[4\].id.d2 dstage\[4\].id.out
+ VDD VDD VSS VSS gf180mcu_fd_sc_mcu7t5v0__invz_2
Xdstage\[11\].id.trim0bar dstage\[11\].id.ltrim\[0\] dstage\[11\].id.ltrimb\[0\] VDD
+ VDD VSS VSS gf180mcu_fd_sc_mcu7t5v0__inv_1
XFILLER_4_25 VDD VDD VSS VSS gf180mcu_fd_sc_mcu7t5v0__fill_1
XANTENNA_dstage\[3\].id.t0_latch_D trim[3] VDD VDD VSS VSS gf180mcu_fd_sc_mcu7t5v0__antenna
Xdstage\[9\].id.hold_out dstage\[10\].id.in VDD VDD VSS VSS gf180mcu_fd_sc_mcu7t5v0__hold
Xdstage\[4\].id.trim1bar dstage\[4\].id.ltrim\[1\] dstage\[4\].id.ltrimb\[1\] VDD
+ VDD VSS VSS gf180mcu_fd_sc_mcu7t5v0__inv_1
XFILLER_6_2 VDD VDD VSS VSS gf180mcu_fd_sc_mcu7t5v0__fill_1
Xdstage\[10\].id.delaybuf1 dstage\[10\].id.ts dstage\[10\].id.d0 VDD VDD VSS VSS gf180mcu_fd_sc_mcu7t5v0__clkbuf_1
XPHY_EDGE_ROW_18_Right_18 VDD VSS gf180mcu_fd_sc_mcu7t5v0__endcap
Xdstage\[5\].id.deglitch_buf dstage\[5\].id.out dstage\[5\].id.out_del VDD VDD VSS
+ VSS gf180mcu_fd_sc_mcu7t5v0__clkbuf_2
Xdstage\[3\].id.delaybuf0 dstage\[2\].id.out dstage\[3\].id.ts VDD VDD VSS VSS gf180mcu_fd_sc_mcu7t5v0__clkbuf_2
XTAP_TAPCELL_ROW_6_58 VDD VSS gf180mcu_fd_sc_mcu7t5v0__filltie
Xdstage\[6\].id.delayint0 dstage\[6\].id.d1 dstage\[6\].id.d2 VDD VDD VSS VSS gf180mcu_fd_sc_mcu7t5v0__clkinv_2
XTAP_TAPCELL_ROW_21_89 VDD VSS gf180mcu_fd_sc_mcu7t5v0__filltie
Xdstage\[8\].id.trim_inhibit dstage\[5\].id.out dstage\[8\].id.out_del dstage\[8\].id.not_edge
+ VDD VDD VSS VSS gf180mcu_fd_sc_mcu7t5v0__xor2_1
Xdstage\[2\].id.hold_d1 dstage\[2\].id.d1 VDD VDD VSS VSS gf180mcu_fd_sc_mcu7t5v0__hold
XTAP_TAPCELL_ROW_16_78 VDD VSS gf180mcu_fd_sc_mcu7t5v0__filltie
XPHY_EDGE_ROW_10_Left_32 VDD VSS gf180mcu_fd_sc_mcu7t5v0__endcap
Xdstage\[4\].id.delayen1 dstage\[4\].id.ltrim\[1\] dstage\[4\].id.d0 dstage\[4\].id.d1
+ VDD VDD VSS VSS gf180mcu_fd_sc_mcu7t5v0__invz_2
XPHY_EDGE_ROW_0_Right_0 VDD VSS gf180mcu_fd_sc_mcu7t5v0__endcap
XFILLER_21_2 VDD VDD VSS VSS gf180mcu_fd_sc_mcu7t5v0__fill_1
Xdstage\[9\].id.t1_latch trim[22] dstage\[9\].id.not_edge dstage\[10\].id.nreset dstage\[9\].id.ltrim\[1\]
+ VDD VDD VSS VSS gf180mcu_fd_sc_mcu7t5v0__latrnq_1
Xdstage\[3\].id.trim0bar dstage\[3\].id.ltrim\[0\] dstage\[3\].id.ltrimb\[0\] VDD
+ VDD VSS VSS gf180mcu_fd_sc_mcu7t5v0__inv_1
Xdstage\[7\].id.hold_d1 dstage\[7\].id.d1 VDD VDD VSS VSS gf180mcu_fd_sc_mcu7t5v0__hold
XFILLER_10_25 VDD VDD VSS VSS gf180mcu_fd_sc_mcu7t5v0__fill_1
Xdstage\[10\].id.deglitch_buf dstage\[10\].id.out dstage\[10\].id.out_del VDD VDD
+ VSS VSS gf180mcu_fd_sc_mcu7t5v0__clkbuf_2
XTAP_TAPCELL_ROW_6_59 VDD VSS gf180mcu_fd_sc_mcu7t5v0__filltie
Xid0.hold_out dstage\[3\].id.prev_in VDD VDD VSS VSS gf180mcu_fd_sc_mcu7t5v0__hold
Xiss.trim_inhibit dstage\[10\].id.in iss.out_del iss.not_edge VDD VDD VSS VSS gf180mcu_fd_sc_mcu7t5v0__xor2_1
Xdstage\[3\].id.delaybuf1 dstage\[3\].id.ts dstage\[3\].id.d0 VDD VDD VSS VSS gf180mcu_fd_sc_mcu7t5v0__clkbuf_1
XFILLER_18_132 VDD VDD VSS VSS gf180mcu_fd_sc_mcu7t5v0__fillcap_16
XTAP_TAPCELL_ROW_16_79 VDD VSS gf180mcu_fd_sc_mcu7t5v0__filltie
XFILLER_21_138 VDD VDD VSS VSS gf180mcu_fd_sc_mcu7t5v0__fillcap_16
XFILLER_7_142 VDD VDD VSS VSS gf180mcu_fd_sc_mcu7t5v0__fillcap_8
XFILLER_14_2 VDD VDD VSS VSS gf180mcu_fd_sc_mcu7t5v0__fill_1
XANTENNA_dstage\[10\].id.t1_latch_D trim[23] VDD VDD VSS VSS gf180mcu_fd_sc_mcu7t5v0__antenna
Xid1.delayenb0 id1.ltrimb\[0\] id1.ts dstage\[2\].id.in VDD VDD VSS VSS gf180mcu_fd_sc_mcu7t5v0__invz_8
Xdstage\[9\].id.t0_latch trim[9] dstage\[9\].id.not_edge dstage\[10\].id.nreset dstage\[9\].id.ltrim\[0\]
+ VDD VDD VSS VSS gf180mcu_fd_sc_mcu7t5v0__latrnq_1
Xid0.t1_latch trim[13] id0.not_edge dstage\[10\].id.nreset id0.ltrim\[1\] VDD VDD
+ VSS VSS gf180mcu_fd_sc_mcu7t5v0__latrnq_1
Xdstage\[2\].id.delayint0 dstage\[2\].id.d1 dstage\[2\].id.d2 VDD VDD VSS VSS gf180mcu_fd_sc_mcu7t5v0__clkinv_2
XFILLER_11_150 VDD VDD VSS VSS gf180mcu_fd_sc_mcu7t5v0__fillcap_4
XANTENNA_iss.ctrlen0_A1 reset VDD VDD VSS VSS gf180mcu_fd_sc_mcu7t5v0__antenna
XFILLER_1_138 VDD VDD VSS VSS gf180mcu_fd_sc_mcu7t5v0__fill_2
Xid0.deglitch_buf dstage\[3\].id.prev_in id0.out_del VDD VDD VSS VSS gf180mcu_fd_sc_mcu7t5v0__clkbuf_2
Xid1.delayenb1 id1.ltrimb\[1\] id1.ts id1.d1 VDD VDD VSS VSS gf180mcu_fd_sc_mcu7t5v0__invz_4
XPHY_EDGE_ROW_14_Right_14 VDD VSS gf180mcu_fd_sc_mcu7t5v0__endcap
XFILLER_4_2 VDD VDD VSS VSS gf180mcu_fd_sc_mcu7t5v0__fill_1
XFILLER_2_61 VDD VDD VSS VSS gf180mcu_fd_sc_mcu7t5v0__fill_1
XTAP_TAPCELL_ROW_7_60 VDD VSS gf180mcu_fd_sc_mcu7t5v0__filltie
XFILLER_20_151 VDD VDD VSS VSS gf180mcu_fd_sc_mcu7t5v0__fill_2
XFILLER_16_37 VDD VDD VSS VSS gf180mcu_fd_sc_mcu7t5v0__fill_1
Xid0.t0_latch trim[0] id0.not_edge dstage\[10\].id.nreset id0.ltrim\[0\] VDD VDD VSS
+ VSS gf180mcu_fd_sc_mcu7t5v0__latrnq_1
XPHY_EDGE_ROW_4_Right_4 VDD VSS gf180mcu_fd_sc_mcu7t5v0__endcap
XPHY_EDGE_ROW_14_Left_36 VDD VSS gf180mcu_fd_sc_mcu7t5v0__endcap
Xdstage\[3\].id.trim_inhibit dstage\[3\].id.prev_in dstage\[3\].id.out_del dstage\[3\].id.not_edge
+ VDD VDD VSS VSS gf180mcu_fd_sc_mcu7t5v0__xor2_1
XTAP_TAPCELL_ROW_17_80 VDD VSS gf180mcu_fd_sc_mcu7t5v0__filltie
Xdstage\[6\].id.hold_out dstage\[6\].id.out VDD VDD VSS VSS gf180mcu_fd_sc_mcu7t5v0__hold
Xid1.delaybuf0 dstage\[3\].id.prev_in id1.ts VDD VDD VSS VSS gf180mcu_fd_sc_mcu7t5v0__clkbuf_2
XPHY_EDGE_ROW_2_Left_24 VDD VSS gf180mcu_fd_sc_mcu7t5v0__endcap
XANTENNA_dstage\[5\].id.t1_latch_D trim[18] VDD VDD VSS VSS gf180mcu_fd_sc_mcu7t5v0__antenna
XTAP_TAPCELL_ROW_7_61 VDD VSS gf180mcu_fd_sc_mcu7t5v0__filltie
XANTENNA_iss.reseten0_EN reset VDD VDD VSS VSS gf180mcu_fd_sc_mcu7t5v0__antenna
XTAP_TAPCELL_ROW_17_81 VDD VSS gf180mcu_fd_sc_mcu7t5v0__filltie
XFILLER_12_2 VDD VDD VSS VSS gf180mcu_fd_sc_mcu7t5v0__fill_1
Xdstage\[6\].id.t1_latch trim[19] dstage\[6\].id.not_edge dstage\[10\].id.nreset dstage\[6\].id.ltrim\[1\]
+ VDD VDD VSS VSS gf180mcu_fd_sc_mcu7t5v0__latrnq_1
XANTENNA_dstage\[9\].id.t0_latch_D trim[9] VDD VDD VSS VSS gf180mcu_fd_sc_mcu7t5v0__antenna
Xdstage\[9\].id.delayen0 dstage\[9\].id.ltrim\[0\] dstage\[9\].id.d2 dstage\[10\].id.in
+ VDD VDD VSS VSS gf180mcu_fd_sc_mcu7t5v0__invz_2
XFILLER_14_82 VDD VDD VSS VSS gf180mcu_fd_sc_mcu7t5v0__fill_1
Xid1.delaybuf1 id1.ts id1.d0 VDD VDD VSS VSS gf180mcu_fd_sc_mcu7t5v0__clkbuf_1
Xid1.trim_inhibit dstage\[11\].id.out id1.out_del id1.not_edge VDD VDD VSS VSS gf180mcu_fd_sc_mcu7t5v0__xor2_1
Xdstage\[6\].id.delayenb0 dstage\[6\].id.ltrimb\[0\] dstage\[6\].id.ts dstage\[6\].id.out
+ VDD VDD VSS VSS gf180mcu_fd_sc_mcu7t5v0__invz_8
XFILLER_11_72 VDD VDD VSS VSS gf180mcu_fd_sc_mcu7t5v0__fill_1
Xdstage\[8\].id.deglitch_buf dstage\[11\].id.prev_in dstage\[8\].id.out_del VDD VDD
+ VSS VSS gf180mcu_fd_sc_mcu7t5v0__clkbuf_2
Xdstage\[9\].id.trim1bar dstage\[9\].id.ltrim\[1\] dstage\[9\].id.ltrimb\[1\] VDD
+ VDD VSS VSS gf180mcu_fd_sc_mcu7t5v0__inv_1
Xiss.ctrlen0 reset iss.ltrim\[0\] iss.ctrl0b VDD VDD VSS VSS gf180mcu_fd_sc_mcu7t5v0__nor2_2
XFILLER_20_153 VDD VDD VSS VSS gf180mcu_fd_sc_mcu7t5v0__fill_1
XFILLER_11_131 VDD VDD VSS VSS gf180mcu_fd_sc_mcu7t5v0__fillcap_8
XFILLER_11_142 VDD VDD VSS VSS gf180mcu_fd_sc_mcu7t5v0__fillcap_8
XFILLER_7_135 VDD VDD VSS VSS gf180mcu_fd_sc_mcu7t5v0__fillcap_4
Xid0.delayint0 id0.d1 id0.d2 VDD VDD VSS VSS gf180mcu_fd_sc_mcu7t5v0__clkinv_2
XFILLER_4_138 VDD VDD VSS VSS gf180mcu_fd_sc_mcu7t5v0__fillcap_16
XANTENNA__0__I reset VDD VDD VSS VSS gf180mcu_fd_sc_mcu7t5v0__antenna
Xdstage\[9\].id.delayen1 dstage\[9\].id.ltrim\[1\] dstage\[9\].id.d0 dstage\[9\].id.d1
+ VDD VDD VSS VSS gf180mcu_fd_sc_mcu7t5v0__invz_2
Xdstage\[6\].id.t0_latch trim[6] dstage\[6\].id.not_edge dstage\[10\].id.nreset dstage\[6\].id.ltrim\[0\]
+ VDD VDD VSS VSS gf180mcu_fd_sc_mcu7t5v0__latrnq_1
Xiss.deglitch_buf dstage\[2\].id.prev_in iss.out_del VDD VDD VSS VSS gf180mcu_fd_sc_mcu7t5v0__clkbuf_2
XFILLER_18_148 VDD VDD VSS VSS gf180mcu_fd_sc_mcu7t5v0__fillcap_4
Xdstage\[11\].id.hold_out dstage\[11\].id.out VDD VDD VSS VSS gf180mcu_fd_sc_mcu7t5v0__hold
XPHY_EDGE_ROW_10_Right_10 VDD VSS gf180mcu_fd_sc_mcu7t5v0__endcap
Xid0.delayen0 id0.ltrim\[0\] id0.d2 dstage\[3\].id.prev_in VDD VDD VSS VSS gf180mcu_fd_sc_mcu7t5v0__invz_2
Xdstage\[6\].id.delayenb1 dstage\[6\].id.ltrimb\[1\] dstage\[6\].id.ts dstage\[6\].id.d1
+ VDD VDD VSS VSS gf180mcu_fd_sc_mcu7t5v0__invz_4
XFILLER_2_2 VDD VDD VSS VSS gf180mcu_fd_sc_mcu7t5v0__fill_1
Xdstage\[8\].id.trim0bar dstage\[8\].id.ltrim\[0\] dstage\[8\].id.ltrimb\[0\] VDD
+ VDD VSS VSS gf180mcu_fd_sc_mcu7t5v0__inv_1
XANTENNA_dstage\[4\].id.t0_latch_D trim[4] VDD VDD VSS VSS gf180mcu_fd_sc_mcu7t5v0__antenna
Xid0.trim1bar id0.ltrim\[1\] id0.ltrimb\[1\] VDD VDD VSS VSS gf180mcu_fd_sc_mcu7t5v0__inv_1
XFILLER_17_72 VDD VDD VSS VSS gf180mcu_fd_sc_mcu7t5v0__fill_1
XPHY_EDGE_ROW_8_Right_8 VDD VSS gf180mcu_fd_sc_mcu7t5v0__endcap
X_0_ reset dstage\[10\].id.nreset VDD VDD VSS VSS gf180mcu_fd_sc_mcu7t5v0__clkinv_1
Xdstage\[11\].id.t1_latch trim[24] dstage\[11\].id.not_edge dstage\[10\].id.nreset
+ dstage\[11\].id.ltrim\[1\] VDD VDD VSS VSS gf180mcu_fd_sc_mcu7t5v0__latrnq_1
Xid0.delayen1 id0.ltrim\[1\] id0.d0 id0.d1 VDD VDD VSS VSS gf180mcu_fd_sc_mcu7t5v0__invz_2
XPHY_EDGE_ROW_6_Left_28 VDD VSS gf180mcu_fd_sc_mcu7t5v0__endcap
Xiss.hold_d1 iss.d1 VDD VDD VSS VSS gf180mcu_fd_sc_mcu7t5v0__hold
Xdstage\[6\].id.delaybuf0 dstage\[5\].id.out dstage\[6\].id.ts VDD VDD VSS VSS gf180mcu_fd_sc_mcu7t5v0__clkbuf_2
Xdstage\[2\].id.delayenb0 dstage\[2\].id.ltrimb\[0\] dstage\[2\].id.ts dstage\[2\].id.out
+ VDD VDD VSS VSS gf180mcu_fd_sc_mcu7t5v0__invz_8
Xdstage\[9\].id.delayint0 dstage\[9\].id.d1 dstage\[9\].id.d2 VDD VDD VSS VSS gf180mcu_fd_sc_mcu7t5v0__clkinv_2
XPHY_EDGE_ROW_9_Left_31 VDD VSS gf180mcu_fd_sc_mcu7t5v0__endcap
XFILLER_4_107 VDD VDD VSS VSS gf180mcu_fd_sc_mcu7t5v0__fill_1
Xdstage\[3\].id.hold_out dstage\[3\].id.out VDD VDD VSS VSS gf180mcu_fd_sc_mcu7t5v0__hold
Xdstage\[3\].id.hold_d1 dstage\[3\].id.d1 VDD VDD VSS VSS gf180mcu_fd_sc_mcu7t5v0__hold
XTAP_TAPCELL_ROW_4_54 VDD VSS gf180mcu_fd_sc_mcu7t5v0__filltie
XFILLER_0_132 VDD VDD VSS VSS gf180mcu_fd_sc_mcu7t5v0__fillcap_4
XFILLER_10_2 VDD VDD VSS VSS gf180mcu_fd_sc_mcu7t5v0__fill_1
XTAP_TAPCELL_ROW_14_74 VDD VSS gf180mcu_fd_sc_mcu7t5v0__filltie
XFILLER_17_150 VDD VDD VSS VSS gf180mcu_fd_sc_mcu7t5v0__fillcap_4
Xdstage\[8\].id.hold_d1 dstage\[8\].id.d1 VDD VDD VSS VSS gf180mcu_fd_sc_mcu7t5v0__hold
XFILLER_14_153 VDD VDD VSS VSS gf180mcu_fd_sc_mcu7t5v0__fill_1
Xdstage\[6\].id.delaybuf1 dstage\[6\].id.ts dstage\[6\].id.d0 VDD VDD VSS VSS gf180mcu_fd_sc_mcu7t5v0__clkbuf_1
Xdstage\[2\].id.delayenb1 dstage\[2\].id.ltrimb\[1\] dstage\[2\].id.ts dstage\[2\].id.d1
+ VDD VDD VSS VSS gf180mcu_fd_sc_mcu7t5v0__invz_4
Xdstage\[11\].id.t0_latch trim[11] dstage\[11\].id.not_edge dstage\[10\].id.nreset
+ dstage\[11\].id.ltrim\[0\] VDD VDD VSS VSS gf180mcu_fd_sc_mcu7t5v0__latrnq_1
XANTENNA_dstage\[11\].id.t1_latch_D trim[24] VDD VDD VSS VSS gf180mcu_fd_sc_mcu7t5v0__antenna
Xdstage\[3\].id.t1_latch trim[16] dstage\[3\].id.not_edge dstage\[10\].id.nreset dstage\[3\].id.ltrim\[1\]
+ VDD VDD VSS VSS gf180mcu_fd_sc_mcu7t5v0__latrnq_1
Xdstage\[3\].id.deglitch_buf dstage\[3\].id.out dstage\[3\].id.out_del VDD VDD VSS
+ VSS gf180mcu_fd_sc_mcu7t5v0__clkbuf_2
XTAP_TAPCELL_ROW_4_55 VDD VSS gf180mcu_fd_sc_mcu7t5v0__filltie
XFILLER_3_152 VDD VDD VSS VSS gf180mcu_fd_sc_mcu7t5v0__fill_2
Xdstage\[6\].id.trim_inhibit dstage\[3\].id.out dstage\[6\].id.out_del dstage\[6\].id.not_edge
+ VDD VDD VSS VSS gf180mcu_fd_sc_mcu7t5v0__xor2_1
Xdstage\[6\].id.delayen0 dstage\[6\].id.ltrim\[0\] dstage\[6\].id.d2 dstage\[6\].id.out
+ VDD VDD VSS VSS gf180mcu_fd_sc_mcu7t5v0__invz_2
XANTENNA_iss.t1_latch_D trim[25] VDD VDD VSS VSS gf180mcu_fd_sc_mcu7t5v0__antenna
XTAP_TAPCELL_ROW_14_75 VDD VSS gf180mcu_fd_sc_mcu7t5v0__filltie
XFILLER_18_107 VDD VDD VSS VSS gf180mcu_fd_sc_mcu7t5v0__fill_2
Xdstage\[6\].id.trim1bar dstage\[6\].id.ltrim\[1\] dstage\[6\].id.ltrimb\[1\] VDD
+ VDD VSS VSS gf180mcu_fd_sc_mcu7t5v0__inv_1
XFILLER_11_65 VDD VDD VSS VSS gf180mcu_fd_sc_mcu7t5v0__fill_1
XFILLER_20_135 VDD VDD VSS VSS gf180mcu_fd_sc_mcu7t5v0__fillcap_16
XFILLER_7_139 VDD VDD VSS VSS gf180mcu_fd_sc_mcu7t5v0__fill_1
XFILLER_0_2 VDD VDD VSS VSS gf180mcu_fd_sc_mcu7t5v0__fill_1
Xdstage\[2\].id.delaybuf0 dstage\[2\].id.in dstage\[2\].id.ts VDD VDD VSS VSS gf180mcu_fd_sc_mcu7t5v0__clkbuf_2
Xdstage\[5\].id.delayint0 dstage\[5\].id.d1 dstage\[5\].id.d2 VDD VDD VSS VSS gf180mcu_fd_sc_mcu7t5v0__clkinv_2
Xdstage\[11\].id.trim_inhibit dstage\[11\].id.prev_in dstage\[11\].id.out_del dstage\[11\].id.not_edge
+ VDD VDD VSS VSS gf180mcu_fd_sc_mcu7t5v0__xor2_1
XPHY_EDGE_ROW_17_Right_17 VDD VSS gf180mcu_fd_sc_mcu7t5v0__endcap
Xdstage\[6\].id.delayen1 dstage\[6\].id.ltrim\[1\] dstage\[6\].id.d0 dstage\[6\].id.d1
+ VDD VDD VSS VSS gf180mcu_fd_sc_mcu7t5v0__invz_2
Xdstage\[3\].id.t0_latch trim[3] dstage\[3\].id.not_edge dstage\[10\].id.nreset dstage\[3\].id.ltrim\[0\]
+ VDD VDD VSS VSS gf180mcu_fd_sc_mcu7t5v0__latrnq_1
Xid1.deglitch_buf dstage\[2\].id.in id1.out_del VDD VDD VSS VSS gf180mcu_fd_sc_mcu7t5v0__clkbuf_2
Xdstage\[5\].id.trim0bar dstage\[5\].id.ltrim\[0\] dstage\[5\].id.ltrimb\[0\] VDD
+ VDD VSS VSS gf180mcu_fd_sc_mcu7t5v0__inv_1
XFILLER_6_151 VDD VDD VSS VSS gf180mcu_fd_sc_mcu7t5v0__fill_2
Xid0.delayenb0 id0.ltrimb\[0\] id0.ts dstage\[3\].id.prev_in VDD VDD VSS VSS gf180mcu_fd_sc_mcu7t5v0__invz_8
Xdstage\[2\].id.delaybuf1 dstage\[2\].id.ts dstage\[2\].id.d0 VDD VDD VSS VSS gf180mcu_fd_sc_mcu7t5v0__clkbuf_1
XANTENNA_dstage\[10\].id.t0_latch_D trim[10] VDD VDD VSS VSS gf180mcu_fd_sc_mcu7t5v0__antenna
XANTENNA_dstage\[6\].id.t1_latch_D trim[19] VDD VDD VSS VSS gf180mcu_fd_sc_mcu7t5v0__antenna
Xdstage\[10\].id.hold_d1 dstage\[10\].id.d1 VDD VDD VSS VSS gf180mcu_fd_sc_mcu7t5v0__hold
XFILLER_2_25 VDD VDD VSS VSS gf180mcu_fd_sc_mcu7t5v0__fill_1
XFILLER_17_142 VDD VDD VSS VSS gf180mcu_fd_sc_mcu7t5v0__fillcap_8
Xdstage\[11\].id.delayen0 dstage\[11\].id.ltrim\[0\] dstage\[11\].id.d2 dstage\[11\].id.out
+ VDD VDD VSS VSS gf180mcu_fd_sc_mcu7t5v0__invz_2
XFILLER_8_46 VDD VDD VSS VSS gf180mcu_fd_sc_mcu7t5v0__fill_1
XFILLER_19_2 VDD VDD VSS VSS gf180mcu_fd_sc_mcu7t5v0__fill_1
Xid0.delayenb1 id0.ltrimb\[1\] id0.ts id0.d1 VDD VDD VSS VSS gf180mcu_fd_sc_mcu7t5v0__invz_4
Xdstage\[11\].id.trim1bar dstage\[11\].id.ltrim\[1\] dstage\[11\].id.ltrimb\[1\] VDD
+ VDD VSS VSS gf180mcu_fd_sc_mcu7t5v0__inv_1
XFILLER_3_144 VDD VDD VSS VSS gf180mcu_fd_sc_mcu7t5v0__fillcap_8
XPHY_EDGE_ROW_3_Right_3 VDD VSS gf180mcu_fd_sc_mcu7t5v0__endcap
XPHY_EDGE_ROW_13_Left_35 VDD VSS gf180mcu_fd_sc_mcu7t5v0__endcap
Xiss.nreset_delay dstage\[10\].id.nreset iss.nreset_del VDD VDD VSS VSS gf180mcu_fd_sc_mcu7t5v0__dlyb_1
XTAP_TAPCELL_ROW_1_48 VDD VSS gf180mcu_fd_sc_mcu7t5v0__filltie
Xiss.hold_out iss.out_precg VDD VDD VSS VSS gf180mcu_fd_sc_mcu7t5v0__hold
Xdstage\[11\].id.delayen1 dstage\[11\].id.ltrim\[1\] dstage\[11\].id.d0 dstage\[11\].id.d1
+ VDD VDD VSS VSS gf180mcu_fd_sc_mcu7t5v0__invz_2
XTAP_TAPCELL_ROW_11_68 VDD VSS gf180mcu_fd_sc_mcu7t5v0__filltie
XPHY_EDGE_ROW_1_Left_23 VDD VSS gf180mcu_fd_sc_mcu7t5v0__endcap
XFILLER_8_69 VDD VDD VSS VSS gf180mcu_fd_sc_mcu7t5v0__fill_1
XFILLER_6_153 VDD VDD VSS VSS gf180mcu_fd_sc_mcu7t5v0__fill_1
XFILLER_6_131 VDD VDD VSS VSS gf180mcu_fd_sc_mcu7t5v0__fillcap_16
Xdstage\[9\].id.delayenb0 dstage\[9\].id.ltrimb\[0\] dstage\[9\].id.ts dstage\[10\].id.in
+ VDD VDD VSS VSS gf180mcu_fd_sc_mcu7t5v0__invz_8
XFILLER_0_70 VDD VDD VSS VSS gf180mcu_fd_sc_mcu7t5v0__fill_1
Xdstage\[3\].id.delayen0 dstage\[3\].id.ltrim\[0\] dstage\[3\].id.d2 dstage\[3\].id.out
+ VDD VDD VSS VSS gf180mcu_fd_sc_mcu7t5v0__invz_2
Xdstage\[10\].id.trim0bar dstage\[10\].id.ltrim\[0\] dstage\[10\].id.ltrimb\[0\] VDD
+ VDD VSS VSS gf180mcu_fd_sc_mcu7t5v0__inv_1
Xid0.delaybuf0 dstage\[2\].id.prev_in id0.ts VDD VDD VSS VSS gf180mcu_fd_sc_mcu7t5v0__clkbuf_2
XPHY_EDGE_ROW_13_Right_13 VDD VSS gf180mcu_fd_sc_mcu7t5v0__endcap
XTAP_TAPCELL_ROW_1_49 VDD VSS gf180mcu_fd_sc_mcu7t5v0__filltie
XFILLER_14_46 VDD VDD VSS VSS gf180mcu_fd_sc_mcu7t5v0__fill_1
Xdstage\[8\].id.hold_out dstage\[11\].id.prev_in VDD VDD VSS VSS gf180mcu_fd_sc_mcu7t5v0__hold
Xdstage\[3\].id.trim1bar dstage\[3\].id.ltrim\[1\] dstage\[3\].id.ltrimb\[1\] VDD
+ VDD VSS VSS gf180mcu_fd_sc_mcu7t5v0__inv_1
XTAP_TAPCELL_ROW_11_69 VDD VSS gf180mcu_fd_sc_mcu7t5v0__filltie
Xiss.t1_latch trim[25] iss.not_edge dstage\[10\].id.nreset iss.ltrim\[1\] VDD VDD
+ VSS VSS gf180mcu_fd_sc_mcu7t5v0__latrnq_1
XFILLER_11_139 VDD VDD VSS VSS gf180mcu_fd_sc_mcu7t5v0__fill_1
Xibufp10 dstage\[5\].id.out c\[1\] VDD VDD VSS VSS gf180mcu_fd_sc_mcu7t5v0__clkinv_2
XANTENNA_dstage\[5\].id.t0_latch_D trim[5] VDD VDD VSS VSS gf180mcu_fd_sc_mcu7t5v0__antenna
Xdstage\[9\].id.delayenb1 dstage\[9\].id.ltrimb\[1\] dstage\[9\].id.ts dstage\[9\].id.d1
+ VDD VDD VSS VSS gf180mcu_fd_sc_mcu7t5v0__invz_4
XFILLER_0_138 VDD VDD VSS VSS gf180mcu_fd_sc_mcu7t5v0__fillcap_16
Xdstage\[3\].id.delayen1 dstage\[3\].id.ltrim\[1\] dstage\[3\].id.d0 dstage\[3\].id.d1
+ VDD VDD VSS VSS gf180mcu_fd_sc_mcu7t5v0__invz_2
Xid0.delaybuf1 id0.ts id0.d0 VDD VDD VSS VSS gf180mcu_fd_sc_mcu7t5v0__clkbuf_1
Xdstage\[6\].id.deglitch_buf dstage\[6\].id.out dstage\[6\].id.out_del VDD VDD VSS
+ VSS gf180mcu_fd_sc_mcu7t5v0__clkbuf_2
Xdstage\[9\].id.trim_inhibit dstage\[6\].id.out dstage\[9\].id.out_del dstage\[9\].id.not_edge
+ VDD VDD VSS VSS gf180mcu_fd_sc_mcu7t5v0__xor2_1
Xdstage\[8\].id.t1_latch trim[21] dstage\[8\].id.not_edge dstage\[10\].id.nreset dstage\[8\].id.ltrim\[1\]
+ VDD VDD VSS VSS gf180mcu_fd_sc_mcu7t5v0__latrnq_1
Xdstage\[2\].id.trim0bar dstage\[2\].id.ltrim\[0\] dstage\[2\].id.ltrimb\[0\] VDD
+ VDD VSS VSS gf180mcu_fd_sc_mcu7t5v0__inv_1
XFILLER_14_137 VDD VDD VSS VSS gf180mcu_fd_sc_mcu7t5v0__fillcap_16
XFILLER_9_152 VDD VDD VSS VSS gf180mcu_fd_sc_mcu7t5v0__fill_2
Xibufp00 dstage\[2\].id.prev_in c\[0\] VDD VDD VSS VSS gf180mcu_fd_sc_mcu7t5v0__clkinv_2
Xibufp11 c\[1\] clockp[1] VDD VDD VSS VSS gf180mcu_fd_sc_mcu7t5v0__clkinv_8
XFILLER_10_151 VDD VDD VSS VSS gf180mcu_fd_sc_mcu7t5v0__fill_2
Xiss.t0_latch trim[12] iss.not_edge dstage\[10\].id.nreset iss.ltrim\[0\] VDD VDD
+ VSS VSS gf180mcu_fd_sc_mcu7t5v0__latrnq_1
Xdstage\[9\].id.delaybuf0 dstage\[11\].id.prev_in dstage\[9\].id.ts VDD VDD VSS VSS
+ gf180mcu_fd_sc_mcu7t5v0__clkbuf_2
Xdstage\[5\].id.delayenb0 dstage\[5\].id.ltrimb\[0\] dstage\[5\].id.ts dstage\[5\].id.out
+ VDD VDD VSS VSS gf180mcu_fd_sc_mcu7t5v0__invz_8
Xdstage\[11\].id.deglitch_buf dstage\[11\].id.out dstage\[11\].id.out_del VDD VDD
+ VSS VSS gf180mcu_fd_sc_mcu7t5v0__clkbuf_2
XPHY_EDGE_ROW_17_Left_39 VDD VSS gf180mcu_fd_sc_mcu7t5v0__endcap
XPHY_EDGE_ROW_7_Right_7 VDD VSS gf180mcu_fd_sc_mcu7t5v0__endcap
Xdstage\[4\].id.hold_d1 dstage\[4\].id.d1 VDD VDD VSS VSS gf180mcu_fd_sc_mcu7t5v0__hold
XTAP_TAPCELL_ROW_2_50 VDD VSS gf180mcu_fd_sc_mcu7t5v0__filltie
Xibufp01 c\[0\] clockp[0] VDD VDD VSS VSS gf180mcu_fd_sc_mcu7t5v0__clkinv_8
XFILLER_3_72 VDD VDD VSS VSS gf180mcu_fd_sc_mcu7t5v0__fill_1
Xdstage\[8\].id.t0_latch trim[8] dstage\[8\].id.not_edge dstage\[10\].id.nreset dstage\[8\].id.ltrim\[0\]
+ VDD VDD VSS VSS gf180mcu_fd_sc_mcu7t5v0__latrnq_1
XTAP_TAPCELL_ROW_12_70 VDD VSS gf180mcu_fd_sc_mcu7t5v0__filltie
XPHY_EDGE_ROW_5_Left_27 VDD VSS gf180mcu_fd_sc_mcu7t5v0__endcap
Xdstage\[9\].id.hold_d1 dstage\[9\].id.d1 VDD VDD VSS VSS gf180mcu_fd_sc_mcu7t5v0__hold
Xdstage\[9\].id.delaybuf1 dstage\[9\].id.ts dstage\[9\].id.d0 VDD VDD VSS VSS gf180mcu_fd_sc_mcu7t5v0__clkbuf_1
Xdstage\[5\].id.delayenb1 dstage\[5\].id.ltrimb\[1\] dstage\[5\].id.ts dstage\[5\].id.d1
+ VDD VDD VSS VSS gf180mcu_fd_sc_mcu7t5v0__invz_4
XPHY_EDGE_ROW_8_Left_30 VDD VSS gf180mcu_fd_sc_mcu7t5v0__endcap
XFILLER_20_81 VDD VDD VSS VSS gf180mcu_fd_sc_mcu7t5v0__fill_1
XTAP_TAPCELL_ROW_2_51 VDD VSS gf180mcu_fd_sc_mcu7t5v0__filltie
XFILLER_7_2 VDD VDD VSS VSS gf180mcu_fd_sc_mcu7t5v0__fill_1
XPHY_EDGE_ROW_21_Left_43 VDD VSS gf180mcu_fd_sc_mcu7t5v0__endcap
XTAP_TAPCELL_ROW_12_71 VDD VSS gf180mcu_fd_sc_mcu7t5v0__filltie
XFILLER_10_153 VDD VDD VSS VSS gf180mcu_fd_sc_mcu7t5v0__fill_1
Xdstage\[5\].id.delaybuf0 dstage\[4\].id.out dstage\[5\].id.ts VDD VDD VSS VSS gf180mcu_fd_sc_mcu7t5v0__clkbuf_2
Xdstage\[8\].id.delayint0 dstage\[8\].id.d1 dstage\[8\].id.d2 VDD VDD VSS VSS gf180mcu_fd_sc_mcu7t5v0__clkinv_2
Xdstage\[5\].id.hold_out dstage\[5\].id.out VDD VDD VSS VSS gf180mcu_fd_sc_mcu7t5v0__hold
XFILLER_14_107 VDD VDD VSS VSS gf180mcu_fd_sc_mcu7t5v0__fillcap_4
Xiss.delayen0 iss.ltrim\[0\] iss.d2 iss.out_precg VDD VDD VSS VSS gf180mcu_fd_sc_mcu7t5v0__invz_2
Xdstage\[4\].id.trim_inhibit dstage\[2\].id.in dstage\[4\].id.out_del dstage\[4\].id.not_edge
+ VDD VDD VSS VSS gf180mcu_fd_sc_mcu7t5v0__xor2_1
XFILLER_3_63 VDD VDD VSS VSS gf180mcu_fd_sc_mcu7t5v0__fill_1
XFILLER_10_143 VDD VDD VSS VSS gf180mcu_fd_sc_mcu7t5v0__fillcap_8
XTAP_TAPCELL_ROW_8_62 VDD VSS gf180mcu_fd_sc_mcu7t5v0__filltie
XFILLER_6_147 VDD VDD VSS VSS gf180mcu_fd_sc_mcu7t5v0__fillcap_4
XFILLER_0_97 VDD VDD VSS VSS gf180mcu_fd_sc_mcu7t5v0__fill_1
Xiss.trim1bar iss.ltrim\[1\] iss.trim1b VDD VDD VSS VSS gf180mcu_fd_sc_mcu7t5v0__inv_2
XTAP_TAPCELL_ROW_18_82 VDD VSS gf180mcu_fd_sc_mcu7t5v0__filltie
XANTENNA_dstage\[11\].id.t0_latch_D trim[11] VDD VDD VSS VSS gf180mcu_fd_sc_mcu7t5v0__antenna
XFILLER_15_2 VDD VDD VSS VSS gf180mcu_fd_sc_mcu7t5v0__fill_1
XANTENNA_dstage\[7\].id.t1_latch_D trim[20] VDD VDD VSS VSS gf180mcu_fd_sc_mcu7t5v0__antenna
Xdstage\[5\].id.delaybuf1 dstage\[5\].id.ts dstage\[5\].id.d0 VDD VDD VSS VSS gf180mcu_fd_sc_mcu7t5v0__clkbuf_1
Xdstage\[5\].id.t1_latch trim[18] dstage\[5\].id.not_edge dstage\[10\].id.nreset dstage\[5\].id.ltrim\[1\]
+ VDD VDD VSS VSS gf180mcu_fd_sc_mcu7t5v0__latrnq_1
XANTENNA_iss.t0_latch_D trim[12] VDD VDD VSS VSS gf180mcu_fd_sc_mcu7t5v0__antenna
Xdstage\[11\].id.delayint0 dstage\[11\].id.d1 dstage\[11\].id.d2 VDD VDD VSS VSS gf180mcu_fd_sc_mcu7t5v0__clkinv_2
XFILLER_17_105 VDD VDD VSS VSS gf180mcu_fd_sc_mcu7t5v0__fill_2
Xdstage\[8\].id.delayen0 dstage\[8\].id.ltrim\[0\] dstage\[8\].id.d2 dstage\[11\].id.prev_in
+ VDD VDD VSS VSS gf180mcu_fd_sc_mcu7t5v0__invz_2
XFILLER_13_152 VDD VDD VSS VSS gf180mcu_fd_sc_mcu7t5v0__fill_2
Xiss.delayen1 iss.ltrim\[1\] iss.d0 iss.d1 VDD VDD VSS VSS gf180mcu_fd_sc_mcu7t5v0__invz_2
Xiss.delayint0 iss.d1 iss.d2 VDD VDD VSS VSS gf180mcu_fd_sc_mcu7t5v0__clkinv_1
Xdstage\[11\].id.hold_d1 dstage\[11\].id.d1 VDD VDD VSS VSS gf180mcu_fd_sc_mcu7t5v0__hold
XTAP_TAPCELL_ROW_8_63 VDD VSS gf180mcu_fd_sc_mcu7t5v0__filltie
Xdstage\[8\].id.trim1bar dstage\[8\].id.ltrim\[1\] dstage\[8\].id.ltrimb\[1\] VDD
+ VDD VSS VSS gf180mcu_fd_sc_mcu7t5v0__inv_1
XFILLER_0_65 VDD VDD VSS VSS gf180mcu_fd_sc_mcu7t5v0__fill_1
XFILLER_2_151 VDD VDD VSS VSS gf180mcu_fd_sc_mcu7t5v0__fill_2
XTAP_TAPCELL_ROW_18_83 VDD VSS gf180mcu_fd_sc_mcu7t5v0__filltie
XFILLER_9_63 VDD VDD VSS VSS gf180mcu_fd_sc_mcu7t5v0__fill_1
Xdstage\[9\].id.deglitch_buf dstage\[10\].id.in dstage\[9\].id.out_del VDD VDD VSS
+ VSS gf180mcu_fd_sc_mcu7t5v0__clkbuf_2
Xdstage\[8\].id.delayen1 dstage\[8\].id.ltrim\[1\] dstage\[8\].id.d0 dstage\[8\].id.d1
+ VDD VDD VSS VSS gf180mcu_fd_sc_mcu7t5v0__invz_2
Xdstage\[4\].id.delayint0 dstage\[4\].id.d1 dstage\[4\].id.d2 VDD VDD VSS VSS gf180mcu_fd_sc_mcu7t5v0__clkinv_2
Xdstage\[5\].id.t0_latch trim[5] dstage\[5\].id.not_edge dstage\[10\].id.nreset dstage\[5\].id.ltrim\[0\]
+ VDD VDD VSS VSS gf180mcu_fd_sc_mcu7t5v0__latrnq_1
Xdstage\[10\].id.hold_out dstage\[10\].id.out VDD VDD VSS VSS gf180mcu_fd_sc_mcu7t5v0__hold
XPHY_EDGE_ROW_16_Right_16 VDD VSS gf180mcu_fd_sc_mcu7t5v0__endcap
XFILLER_5_2 VDD VDD VSS VSS gf180mcu_fd_sc_mcu7t5v0__fill_1
Xid1.trim0bar id1.ltrim\[0\] id1.ltrimb\[0\] VDD VDD VSS VSS gf180mcu_fd_sc_mcu7t5v0__inv_1
XANTENNA_dstage\[2\].id.t1_latch_D trim[15] VDD VDD VSS VSS gf180mcu_fd_sc_mcu7t5v0__antenna
Xdstage\[7\].id.trim0bar dstage\[7\].id.ltrim\[0\] dstage\[7\].id.ltrimb\[0\] VDD
+ VDD VSS VSS gf180mcu_fd_sc_mcu7t5v0__inv_1
XPHY_EDGE_ROW_12_Left_34 VDD VSS gf180mcu_fd_sc_mcu7t5v0__endcap
XPHY_EDGE_ROW_2_Right_2 VDD VSS gf180mcu_fd_sc_mcu7t5v0__endcap
XFILLER_20_2 VDD VDD VSS VSS gf180mcu_fd_sc_mcu7t5v0__fill_1
XFILLER_16_151 VDD VDD VSS VSS gf180mcu_fd_sc_mcu7t5v0__fill_2
XANTENNA_dstage\[6\].id.t0_latch_D trim[6] VDD VDD VSS VSS gf180mcu_fd_sc_mcu7t5v0__antenna
XFILLER_13_121 VDD VDD VSS VSS gf180mcu_fd_sc_mcu7t5v0__fill_1
Xdstage\[10\].id.t1_latch trim[23] dstage\[10\].id.not_edge dstage\[10\].id.nreset
+ dstage\[10\].id.ltrim\[1\] VDD VDD VSS VSS gf180mcu_fd_sc_mcu7t5v0__latrnq_1
XPHY_EDGE_ROW_0_Left_22 VDD VSS gf180mcu_fd_sc_mcu7t5v0__endcap
XFILLER_5_150 VDD VDD VSS VSS gf180mcu_fd_sc_mcu7t5v0__fillcap_4
XFILLER_2_153 VDD VDD VSS VSS gf180mcu_fd_sc_mcu7t5v0__fill_1
Xid1.hold_d1 id1.d1 VDD VDD VSS VSS gf180mcu_fd_sc_mcu7t5v0__hold
Xdstage\[2\].id.hold_out dstage\[2\].id.out VDD VDD VSS VSS gf180mcu_fd_sc_mcu7t5v0__hold
XTAP_TAPCELL_ROW_20_86 VDD VSS gf180mcu_fd_sc_mcu7t5v0__filltie
XANTENNA_id1.t1_latch_D trim[14] VDD VDD VSS VSS gf180mcu_fd_sc_mcu7t5v0__antenna
.ends
